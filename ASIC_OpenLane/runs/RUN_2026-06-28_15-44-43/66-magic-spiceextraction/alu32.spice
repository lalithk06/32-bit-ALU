* NGSPICE file created from alu32.ext - technology: sky130A

* Black-box entry subcircuit for sky130_fd_sc_hd__decap_8 abstract view
.subckt sky130_fd_sc_hd__decap_8 VGND VNB VPB VPWR
.ends

* Black-box entry subcircuit for sky130_fd_sc_hd__xnor2_1 abstract view
.subckt sky130_fd_sc_hd__xnor2_1 A B VGND VNB VPB VPWR Y
.ends

* Black-box entry subcircuit for sky130_fd_sc_hd__tapvpwrvgnd_1 abstract view
.subckt sky130_fd_sc_hd__tapvpwrvgnd_1 VGND VPWR
.ends

* Black-box entry subcircuit for sky130_ef_sc_hd__decap_12 abstract view
.subckt sky130_ef_sc_hd__decap_12 VPWR VGND VPB VNB
.ends

* Black-box entry subcircuit for sky130_fd_sc_hd__decap_6 abstract view
.subckt sky130_fd_sc_hd__decap_6 VGND VNB VPB VPWR
.ends

* Black-box entry subcircuit for sky130_fd_sc_hd__decap_4 abstract view
.subckt sky130_fd_sc_hd__decap_4 VGND VNB VPB VPWR
.ends

* Black-box entry subcircuit for sky130_fd_sc_hd__fill_2 abstract view
.subckt sky130_fd_sc_hd__fill_2 VGND VNB VPB VPWR
.ends

* Black-box entry subcircuit for sky130_fd_sc_hd__dlygate4sd1_1 abstract view
.subckt sky130_fd_sc_hd__dlygate4sd1_1 A VGND VNB VPB VPWR X
.ends

* Black-box entry subcircuit for sky130_fd_sc_hd__a31o_1 abstract view
.subckt sky130_fd_sc_hd__a31o_1 A1 A2 A3 B1 VGND VNB VPB VPWR X
.ends

* Black-box entry subcircuit for sky130_fd_sc_hd__fill_1 abstract view
.subckt sky130_fd_sc_hd__fill_1 VGND VNB VPB VPWR
.ends

* Black-box entry subcircuit for sky130_fd_sc_hd__and2_1 abstract view
.subckt sky130_fd_sc_hd__and2_1 A B VGND VNB VPB VPWR X
.ends

* Black-box entry subcircuit for sky130_fd_sc_hd__a22o_1 abstract view
.subckt sky130_fd_sc_hd__a22o_1 A1 A2 B1 B2 VGND VNB VPB VPWR X
.ends

* Black-box entry subcircuit for sky130_fd_sc_hd__o221a_1 abstract view
.subckt sky130_fd_sc_hd__o221a_1 A1 A2 B1 B2 C1 VGND VNB VPB VPWR X
.ends

* Black-box entry subcircuit for sky130_fd_sc_hd__buf_2 abstract view
.subckt sky130_fd_sc_hd__buf_2 A VGND VNB VPB VPWR X
.ends

* Black-box entry subcircuit for sky130_fd_sc_hd__nand2_1 abstract view
.subckt sky130_fd_sc_hd__nand2_1 A B VGND VNB VPB VPWR Y
.ends

* Black-box entry subcircuit for sky130_fd_sc_hd__clkbuf_4 abstract view
.subckt sky130_fd_sc_hd__clkbuf_4 A VGND VNB VPB VPWR X
.ends

* Black-box entry subcircuit for sky130_fd_sc_hd__mux2_1 abstract view
.subckt sky130_fd_sc_hd__mux2_1 A0 A1 S VGND VNB VPB VPWR X
.ends

* Black-box entry subcircuit for sky130_fd_sc_hd__mux4_1 abstract view
.subckt sky130_fd_sc_hd__mux4_1 A0 A1 A2 A3 S0 S1 VGND VNB VPB VPWR X
.ends

* Black-box entry subcircuit for sky130_fd_sc_hd__decap_3 abstract view
.subckt sky130_fd_sc_hd__decap_3 VGND VNB VPB VPWR
.ends

* Black-box entry subcircuit for sky130_fd_sc_hd__o211ai_1 abstract view
.subckt sky130_fd_sc_hd__o211ai_1 A1 A2 B1 C1 VGND VNB VPB VPWR Y
.ends

* Black-box entry subcircuit for sky130_fd_sc_hd__a211o_1 abstract view
.subckt sky130_fd_sc_hd__a211o_1 A1 A2 B1 C1 VGND VNB VPB VPWR X
.ends

* Black-box entry subcircuit for sky130_fd_sc_hd__a221o_1 abstract view
.subckt sky130_fd_sc_hd__a221o_1 A1 A2 B1 B2 C1 VGND VNB VPB VPWR X
.ends

* Black-box entry subcircuit for sky130_fd_sc_hd__a21o_1 abstract view
.subckt sky130_fd_sc_hd__a21o_1 A1 A2 B1 VGND VNB VPB VPWR X
.ends

* Black-box entry subcircuit for sky130_fd_sc_hd__nor2_1 abstract view
.subckt sky130_fd_sc_hd__nor2_1 A B VGND VNB VPB VPWR Y
.ends

* Black-box entry subcircuit for sky130_fd_sc_hd__or2_1 abstract view
.subckt sky130_fd_sc_hd__or2_1 A B VGND VNB VPB VPWR X
.ends

* Black-box entry subcircuit for sky130_fd_sc_hd__inv_2 abstract view
.subckt sky130_fd_sc_hd__inv_2 A VGND VNB VPB VPWR Y
.ends

* Black-box entry subcircuit for sky130_fd_sc_hd__a2bb2o_4 abstract view
.subckt sky130_fd_sc_hd__a2bb2o_4 A1_N A2_N B1 B2 VGND VNB VPB VPWR X
.ends

* Black-box entry subcircuit for sky130_fd_sc_hd__o21ai_1 abstract view
.subckt sky130_fd_sc_hd__o21ai_1 A1 A2 B1 VGND VNB VPB VPWR Y
.ends

* Black-box entry subcircuit for sky130_fd_sc_hd__o21a_1 abstract view
.subckt sky130_fd_sc_hd__o21a_1 A1 A2 B1 VGND VNB VPB VPWR X
.ends

* Black-box entry subcircuit for sky130_fd_sc_hd__buf_6 abstract view
.subckt sky130_fd_sc_hd__buf_6 A VGND VNB VPB VPWR X
.ends

* Black-box entry subcircuit for sky130_fd_sc_hd__a21bo_1 abstract view
.subckt sky130_fd_sc_hd__a21bo_1 A1 A2 B1_N VGND VNB VPB VPWR X
.ends

* Black-box entry subcircuit for sky130_fd_sc_hd__clkbuf_2 abstract view
.subckt sky130_fd_sc_hd__clkbuf_2 A VGND VNB VPB VPWR X
.ends

* Black-box entry subcircuit for sky130_fd_sc_hd__buf_8 abstract view
.subckt sky130_fd_sc_hd__buf_8 A VGND VNB VPB VPWR X
.ends

* Black-box entry subcircuit for sky130_fd_sc_hd__a22oi_1 abstract view
.subckt sky130_fd_sc_hd__a22oi_1 A1 A2 B1 B2 VGND VNB VPB VPWR Y
.ends

* Black-box entry subcircuit for sky130_fd_sc_hd__nand2_2 abstract view
.subckt sky130_fd_sc_hd__nand2_2 A B VGND VNB VPB VPWR Y
.ends

* Black-box entry subcircuit for sky130_fd_sc_hd__xnor2_2 abstract view
.subckt sky130_fd_sc_hd__xnor2_2 A B VGND VNB VPB VPWR Y
.ends

* Black-box entry subcircuit for sky130_fd_sc_hd__o211a_1 abstract view
.subckt sky130_fd_sc_hd__o211a_1 A1 A2 B1 C1 VGND VNB VPB VPWR X
.ends

* Black-box entry subcircuit for sky130_fd_sc_hd__o31a_1 abstract view
.subckt sky130_fd_sc_hd__o31a_1 A1 A2 A3 B1 VGND VNB VPB VPWR X
.ends

* Black-box entry subcircuit for sky130_fd_sc_hd__o22a_1 abstract view
.subckt sky130_fd_sc_hd__o22a_1 A1 A2 B1 B2 VGND VNB VPB VPWR X
.ends

* Black-box entry subcircuit for sky130_fd_sc_hd__a21oi_1 abstract view
.subckt sky130_fd_sc_hd__a21oi_1 A1 A2 B1 VGND VNB VPB VPWR Y
.ends

* Black-box entry subcircuit for sky130_fd_sc_hd__a2bb2o_1 abstract view
.subckt sky130_fd_sc_hd__a2bb2o_1 A1_N A2_N B1 B2 VGND VNB VPB VPWR X
.ends

* Black-box entry subcircuit for sky130_fd_sc_hd__o2bb2a_1 abstract view
.subckt sky130_fd_sc_hd__o2bb2a_1 A1_N A2_N B1 B2 VGND VNB VPB VPWR X
.ends

* Black-box entry subcircuit for sky130_fd_sc_hd__a31oi_2 abstract view
.subckt sky130_fd_sc_hd__a31oi_2 A1 A2 A3 B1 VGND VNB VPB VPWR Y
.ends

* Black-box entry subcircuit for sky130_fd_sc_hd__and3_1 abstract view
.subckt sky130_fd_sc_hd__and3_1 A B C VGND VNB VPB VPWR X
.ends

* Black-box entry subcircuit for sky130_fd_sc_hd__a311oi_4 abstract view
.subckt sky130_fd_sc_hd__a311oi_4 A1 A2 A3 B1 C1 VGND VNB VPB VPWR Y
.ends

* Black-box entry subcircuit for sky130_fd_sc_hd__a211o_4 abstract view
.subckt sky130_fd_sc_hd__a211o_4 A1 A2 B1 C1 VGND VNB VPB VPWR X
.ends

* Black-box entry subcircuit for sky130_fd_sc_hd__xor2_1 abstract view
.subckt sky130_fd_sc_hd__xor2_1 A B VGND VNB VPB VPWR X
.ends

* Black-box entry subcircuit for sky130_fd_sc_hd__a21oi_4 abstract view
.subckt sky130_fd_sc_hd__a21oi_4 A1 A2 B1 VGND VNB VPB VPWR Y
.ends

* Black-box entry subcircuit for sky130_fd_sc_hd__mux2_2 abstract view
.subckt sky130_fd_sc_hd__mux2_2 A0 A1 S VGND VNB VPB VPWR X
.ends

* Black-box entry subcircuit for sky130_fd_sc_hd__o311a_1 abstract view
.subckt sky130_fd_sc_hd__o311a_1 A1 A2 A3 B1 C1 VGND VNB VPB VPWR X
.ends

* Black-box entry subcircuit for sky130_fd_sc_hd__buf_4 abstract view
.subckt sky130_fd_sc_hd__buf_4 A VGND VNB VPB VPWR X
.ends

* Black-box entry subcircuit for sky130_fd_sc_hd__a211oi_2 abstract view
.subckt sky130_fd_sc_hd__a211oi_2 A1 A2 B1 C1 VGND VNB VPB VPWR Y
.ends

* Black-box entry subcircuit for sky130_fd_sc_hd__or3_4 abstract view
.subckt sky130_fd_sc_hd__or3_4 A B C VGND VNB VPB VPWR X
.ends

* Black-box entry subcircuit for sky130_fd_sc_hd__o2bb2a_4 abstract view
.subckt sky130_fd_sc_hd__o2bb2a_4 A1_N A2_N B1 B2 VGND VNB VPB VPWR X
.ends

* Black-box entry subcircuit for sky130_fd_sc_hd__nand2b_1 abstract view
.subckt sky130_fd_sc_hd__nand2b_1 A_N B VGND VNB VPB VPWR Y
.ends

* Black-box entry subcircuit for sky130_fd_sc_hd__and2_4 abstract view
.subckt sky130_fd_sc_hd__and2_4 A B VGND VNB VPB VPWR X
.ends

* Black-box entry subcircuit for sky130_fd_sc_hd__nor2_2 abstract view
.subckt sky130_fd_sc_hd__nor2_2 A B VGND VNB VPB VPWR Y
.ends

* Black-box entry subcircuit for sky130_fd_sc_hd__and2b_1 abstract view
.subckt sky130_fd_sc_hd__and2b_1 A_N B VGND VNB VPB VPWR X
.ends

* Black-box entry subcircuit for sky130_fd_sc_hd__and2_2 abstract view
.subckt sky130_fd_sc_hd__and2_2 A B VGND VNB VPB VPWR X
.ends

* Black-box entry subcircuit for sky130_fd_sc_hd__nor2_4 abstract view
.subckt sky130_fd_sc_hd__nor2_4 A B VGND VNB VPB VPWR Y
.ends

* Black-box entry subcircuit for sky130_fd_sc_hd__nor3_1 abstract view
.subckt sky130_fd_sc_hd__nor3_1 A B C VGND VNB VPB VPWR Y
.ends

* Black-box entry subcircuit for sky130_fd_sc_hd__or3b_4 abstract view
.subckt sky130_fd_sc_hd__or3b_4 A B C_N VGND VNB VPB VPWR X
.ends

* Black-box entry subcircuit for sky130_fd_sc_hd__or3_1 abstract view
.subckt sky130_fd_sc_hd__or3_1 A B C VGND VNB VPB VPWR X
.ends

* Black-box entry subcircuit for sky130_fd_sc_hd__or2_2 abstract view
.subckt sky130_fd_sc_hd__or2_2 A B VGND VNB VPB VPWR X
.ends

* Black-box entry subcircuit for sky130_fd_sc_hd__or2_4 abstract view
.subckt sky130_fd_sc_hd__or2_4 A B VGND VNB VPB VPWR X
.ends

* Black-box entry subcircuit for sky130_fd_sc_hd__o221a_4 abstract view
.subckt sky130_fd_sc_hd__o221a_4 A1 A2 B1 B2 C1 VGND VNB VPB VPWR X
.ends

* Black-box entry subcircuit for sky130_fd_sc_hd__and3b_1 abstract view
.subckt sky130_fd_sc_hd__and3b_1 A_N B C VGND VNB VPB VPWR X
.ends

* Black-box entry subcircuit for sky130_fd_sc_hd__nor2_8 abstract view
.subckt sky130_fd_sc_hd__nor2_8 A B VGND VNB VPB VPWR Y
.ends

* Black-box entry subcircuit for sky130_fd_sc_hd__nand2_4 abstract view
.subckt sky130_fd_sc_hd__nand2_4 A B VGND VNB VPB VPWR Y
.ends

* Black-box entry subcircuit for sky130_fd_sc_hd__a311o_1 abstract view
.subckt sky130_fd_sc_hd__a311o_1 A1 A2 A3 B1 C1 VGND VNB VPB VPWR X
.ends

* Black-box entry subcircuit for sky130_fd_sc_hd__or4b_4 abstract view
.subckt sky130_fd_sc_hd__or4b_4 A B C D_N VGND VNB VPB VPWR X
.ends

* Black-box entry subcircuit for sky130_fd_sc_hd__or4_1 abstract view
.subckt sky130_fd_sc_hd__or4_1 A B C D VGND VNB VPB VPWR X
.ends

* Black-box entry subcircuit for sky130_fd_sc_hd__o21bai_1 abstract view
.subckt sky130_fd_sc_hd__o21bai_1 A1 A2 B1_N VGND VNB VPB VPWR Y
.ends

* Black-box entry subcircuit for sky130_fd_sc_hd__and4bb_1 abstract view
.subckt sky130_fd_sc_hd__and4bb_1 A_N B_N C D VGND VNB VPB VPWR X
.ends

* Black-box entry subcircuit for sky130_fd_sc_hd__or3b_1 abstract view
.subckt sky130_fd_sc_hd__or3b_1 A B C_N VGND VNB VPB VPWR X
.ends

* Black-box entry subcircuit for sky130_fd_sc_hd__or3_2 abstract view
.subckt sky130_fd_sc_hd__or3_2 A B C VGND VNB VPB VPWR X
.ends

* Black-box entry subcircuit for sky130_fd_sc_hd__o2111a_1 abstract view
.subckt sky130_fd_sc_hd__o2111a_1 A1 A2 B1 C1 D1 VGND VNB VPB VPWR X
.ends

* Black-box entry subcircuit for sky130_fd_sc_hd__and3_4 abstract view
.subckt sky130_fd_sc_hd__and3_4 A B C VGND VNB VPB VPWR X
.ends

* Black-box entry subcircuit for sky130_fd_sc_hd__clkbuf_1 abstract view
.subckt sky130_fd_sc_hd__clkbuf_1 A VGND VNB VPB VPWR X
.ends

* Black-box entry subcircuit for sky130_fd_sc_hd__inv_4 abstract view
.subckt sky130_fd_sc_hd__inv_4 A VGND VNB VPB VPWR Y
.ends

* Black-box entry subcircuit for sky130_fd_sc_hd__buf_1 abstract view
.subckt sky130_fd_sc_hd__buf_1 A VGND VNB VPB VPWR X
.ends

* Black-box entry subcircuit for sky130_fd_sc_hd__o2bb2ai_1 abstract view
.subckt sky130_fd_sc_hd__o2bb2ai_1 A1_N A2_N B1 B2 VGND VNB VPB VPWR Y
.ends

* Black-box entry subcircuit for sky130_fd_sc_hd__a21bo_4 abstract view
.subckt sky130_fd_sc_hd__a21bo_4 A1 A2 B1_N VGND VNB VPB VPWR X
.ends

* Black-box entry subcircuit for sky130_fd_sc_hd__dlymetal6s2s_1 abstract view
.subckt sky130_fd_sc_hd__dlymetal6s2s_1 A VGND VNB VPB VPWR X
.ends

* Black-box entry subcircuit for sky130_fd_sc_hd__mux4_2 abstract view
.subckt sky130_fd_sc_hd__mux4_2 A0 A1 A2 A3 S0 S1 VGND VNB VPB VPWR X
.ends

* Black-box entry subcircuit for sky130_fd_sc_hd__nand2_8 abstract view
.subckt sky130_fd_sc_hd__nand2_8 A B VGND VNB VPB VPWR Y
.ends

* Black-box entry subcircuit for sky130_fd_sc_hd__a21oi_2 abstract view
.subckt sky130_fd_sc_hd__a21oi_2 A1 A2 B1 VGND VNB VPB VPWR Y
.ends

* Black-box entry subcircuit for sky130_fd_sc_hd__and4b_1 abstract view
.subckt sky130_fd_sc_hd__and4b_1 A_N B C D VGND VNB VPB VPWR X
.ends

* Black-box entry subcircuit for sky130_fd_sc_hd__o21bai_4 abstract view
.subckt sky130_fd_sc_hd__o21bai_4 A1 A2 B1_N VGND VNB VPB VPWR Y
.ends

* Black-box entry subcircuit for sky130_fd_sc_hd__a31oi_1 abstract view
.subckt sky130_fd_sc_hd__a31oi_1 A1 A2 A3 B1 VGND VNB VPB VPWR Y
.ends

* Black-box entry subcircuit for sky130_fd_sc_hd__a2bb2oi_1 abstract view
.subckt sky130_fd_sc_hd__a2bb2oi_1 A1_N A2_N B1 B2 VGND VNB VPB VPWR Y
.ends

* Black-box entry subcircuit for sky130_fd_sc_hd__a32o_1 abstract view
.subckt sky130_fd_sc_hd__a32o_1 A1 A2 A3 B1 B2 VGND VNB VPB VPWR X
.ends

* Black-box entry subcircuit for sky130_fd_sc_hd__nor4b_2 abstract view
.subckt sky130_fd_sc_hd__nor4b_2 A B C D_N VGND VNB VPB VPWR Y
.ends

* Black-box entry subcircuit for sky130_fd_sc_hd__a31o_4 abstract view
.subckt sky130_fd_sc_hd__a31o_4 A1 A2 A3 B1 VGND VNB VPB VPWR X
.ends

* Black-box entry subcircuit for sky130_fd_sc_hd__o32a_4 abstract view
.subckt sky130_fd_sc_hd__o32a_4 A1 A2 A3 B1 B2 VGND VNB VPB VPWR X
.ends

* Black-box entry subcircuit for sky130_fd_sc_hd__or4_4 abstract view
.subckt sky130_fd_sc_hd__or4_4 A B C D VGND VNB VPB VPWR X
.ends

* Black-box entry subcircuit for sky130_fd_sc_hd__a32o_2 abstract view
.subckt sky130_fd_sc_hd__a32o_2 A1 A2 A3 B1 B2 VGND VNB VPB VPWR X
.ends

* Black-box entry subcircuit for sky130_fd_sc_hd__a21boi_1 abstract view
.subckt sky130_fd_sc_hd__a21boi_1 A1 A2 B1_N VGND VNB VPB VPWR Y
.ends

* Black-box entry subcircuit for sky130_fd_sc_hd__or4b_1 abstract view
.subckt sky130_fd_sc_hd__or4b_1 A B C D_N VGND VNB VPB VPWR X
.ends

* Black-box entry subcircuit for sky130_fd_sc_hd__a221oi_1 abstract view
.subckt sky130_fd_sc_hd__a221oi_1 A1 A2 B1 B2 C1 VGND VNB VPB VPWR Y
.ends

* Black-box entry subcircuit for sky130_fd_sc_hd__o22ai_1 abstract view
.subckt sky130_fd_sc_hd__o22ai_1 A1 A2 B1 B2 VGND VNB VPB VPWR Y
.ends

* Black-box entry subcircuit for sky130_fd_sc_hd__o211a_4 abstract view
.subckt sky130_fd_sc_hd__o211a_4 A1 A2 B1 C1 VGND VNB VPB VPWR X
.ends

* Black-box entry subcircuit for sky130_fd_sc_hd__o32a_1 abstract view
.subckt sky130_fd_sc_hd__o32a_1 A1 A2 A3 B1 B2 VGND VNB VPB VPWR X
.ends

* Black-box entry subcircuit for sky130_fd_sc_hd__and4_1 abstract view
.subckt sky130_fd_sc_hd__and4_1 A B C D VGND VNB VPB VPWR X
.ends

* Black-box entry subcircuit for sky130_fd_sc_hd__o32ai_4 abstract view
.subckt sky130_fd_sc_hd__o32ai_4 A1 A2 A3 B1 B2 VGND VNB VPB VPWR Y
.ends

* Black-box entry subcircuit for sky130_fd_sc_hd__o21ai_4 abstract view
.subckt sky130_fd_sc_hd__o21ai_4 A1 A2 B1 VGND VNB VPB VPWR Y
.ends

* Black-box entry subcircuit for sky130_fd_sc_hd__a21boi_2 abstract view
.subckt sky130_fd_sc_hd__a21boi_2 A1 A2 B1_N VGND VNB VPB VPWR Y
.ends

* Black-box entry subcircuit for sky130_fd_sc_hd__diode_2 abstract view
.subckt sky130_fd_sc_hd__diode_2 DIODE VGND VNB VPB VPWR
.ends

* Black-box entry subcircuit for sky130_fd_sc_hd__nand3_1 abstract view
.subckt sky130_fd_sc_hd__nand3_1 A B C VGND VNB VPB VPWR Y
.ends

* Black-box entry subcircuit for sky130_fd_sc_hd__and3_2 abstract view
.subckt sky130_fd_sc_hd__and3_2 A B C VGND VNB VPB VPWR X
.ends

.subckt alu32 A[0] A[10] A[11] A[12] A[13] A[14] A[15] A[16] A[17] A[18] A[19] A[1]
+ A[20] A[21] A[22] A[23] A[24] A[25] A[26] A[27] A[28] A[29] A[2] A[30] A[31] A[3]
+ A[4] A[5] A[6] A[7] A[8] A[9] B[0] B[10] B[11] B[12] B[13] B[14] B[15] B[16] B[17]
+ B[18] B[19] B[1] B[20] B[21] B[22] B[23] B[24] B[25] B[26] B[27] B[28] B[29] B[2]
+ B[30] B[31] B[3] B[4] B[5] B[6] B[7] B[8] B[9] C N P Result[0] Result[10] Result[11]
+ Result[12] Result[13] Result[14] Result[15] Result[16] Result[17] Result[18] Result[19]
+ Result[1] Result[20] Result[21] Result[22] Result[23] Result[24] Result[25] Result[26]
+ Result[27] Result[28] Result[29] Result[2] Result[30] Result[31] Result[3] Result[4]
+ Result[5] Result[6] Result[7] Result[8] Result[9] V VGND VPWR Z alu_opcode[0] alu_opcode[1]
+ alu_opcode[2] alu_opcode[3] alu_opcode[4]
XFILLER_36_19 VGND VGND VPWR VPWR sky130_fd_sc_hd__decap_8
X_2037_ net73 net84 VGND VGND VPWR VPWR _0129_ sky130_fd_sc_hd__xnor2_1
XTAP_TAPCELL_ROW_52_404 VGND VPWR sky130_fd_sc_hd__tapvpwrvgnd_1
XFILLER_52_29 VPWR VGND VPWR VGND sky130_ef_sc_hd__decap_12
XFILLER_53_291 VGND VGND VPWR VPWR sky130_fd_sc_hd__decap_6
XFILLER_45_258 VGND VGND VPWR VPWR sky130_fd_sc_hd__decap_4
XFILLER_26_96 VGND VGND VPWR VPWR sky130_fd_sc_hd__decap_8
XFILLER_26_85 VGND VGND VPWR VPWR sky130_fd_sc_hd__fill_2
XFILLER_13_133 VGND VGND VPWR VPWR sky130_fd_sc_hd__decap_4
Xrebuffer7 _0661_ VGND VGND VPWR VPWR net259 sky130_fd_sc_hd__dlygate4sd1_1
X_1270_ _0396_ _0398_ _0399_ net126 VGND VGND VPWR VPWR _0400_ sky130_fd_sc_hd__a31o_1
XFILLER_51_217 VGND VGND VPWR VPWR sky130_fd_sc_hd__fill_1
X_1606_ net183 net39 VGND VGND VPWR VPWR _0724_ sky130_fd_sc_hd__and2_1
XTAP_TAPCELL_ROW_14_194 VGND VPWR sky130_fd_sc_hd__tapvpwrvgnd_1
X_1537_ net111 _0653_ _0657_ net113 VGND VGND VPWR VPWR _0658_ sky130_fd_sc_hd__a22o_1
X_1399_ net228 net118 _0519_ net159 _0524_ VGND VGND VPWR VPWR _0525_ sky130_fd_sc_hd__o221a_1
Xfanout127 net128 VGND VGND VPWR VPWR net127 sky130_fd_sc_hd__buf_2
X_1468_ net242 net34 VGND VGND VPWR VPWR _0591_ sky130_fd_sc_hd__nand2_1
Xfanout116 _0257_ VGND VGND VPWR VPWR net116 sky130_fd_sc_hd__buf_2
Xfanout149 net150 VGND VGND VPWR VPWR net149 sky130_fd_sc_hd__clkbuf_4
Xfanout138 _0206_ VGND VGND VPWR VPWR net138 sky130_fd_sc_hd__buf_2
XFILLER_42_239 VPWR VGND VPWR VGND sky130_ef_sc_hd__decap_12
XFILLER_42_217 VPWR VGND VPWR VGND sky130_ef_sc_hd__decap_12
XFILLER_27_247 VPWR VGND VPWR VGND sky130_ef_sc_hd__decap_12
XFILLER_50_261 VGND VGND VPWR VPWR sky130_fd_sc_hd__fill_2
XFILLER_37_51 VGND VGND VPWR VPWR sky130_fd_sc_hd__decap_4
XFILLER_18_225 VGND VGND VPWR VPWR sky130_fd_sc_hd__decap_8
XFILLER_53_61 VGND VGND VPWR VPWR sky130_fd_sc_hd__decap_6
XFILLER_5_140 VGND VGND VPWR VPWR sky130_fd_sc_hd__decap_6
XTAP_TAPCELL_ROW_11_175 VGND VPWR sky130_fd_sc_hd__tapvpwrvgnd_1
X_1253_ _0279_ _0306_ net178 VGND VGND VPWR VPWR _0383_ sky130_fd_sc_hd__mux2_1
X_1322_ net28 net27 net26 net23 net217 net208 VGND VGND VPWR VPWR _0450_ sky130_fd_sc_hd__mux4_1
XFILLER_5_184 VGND VGND VPWR VPWR sky130_fd_sc_hd__decap_3
X_1184_ net198 net161 net141 _0314_ VGND VGND VPWR VPWR _0315_ sky130_fd_sc_hd__o211ai_1
XTAP_TAPCELL_ROW_19_220 VGND VPWR sky130_fd_sc_hd__tapvpwrvgnd_1
XFILLER_15_217 VGND VGND VPWR VPWR sky130_fd_sc_hd__fill_2
XFILLER_23_250 VPWR VGND VPWR VGND sky130_ef_sc_hd__decap_12
XFILLER_2_176 VGND VGND VPWR VPWR sky130_fd_sc_hd__decap_6
XFILLER_0_57 VGND VGND VPWR VPWR sky130_fd_sc_hd__fill_1
XTAP_TAPCELL_ROW_16_201 VGND VPWR sky130_fd_sc_hd__tapvpwrvgnd_1
X_1871_ net112 _0576_ _0978_ net107 VGND VGND VPWR VPWR _0979_ sky130_fd_sc_hd__a211o_1
X_1940_ _0260_ _0028_ _0027_ VGND VGND VPWR VPWR _0029_ sky130_fd_sc_hd__mux2_1
XFILLER_14_261 VPWR VGND VPWR VGND sky130_ef_sc_hd__decap_12
XFILLER_50_3 VPWR VGND VPWR VGND sky130_ef_sc_hd__decap_12
X_1236_ net193 net136 net133 net233 _0365_ VGND VGND VPWR VPWR _0366_ sky130_fd_sc_hd__a221o_1
X_1305_ _0407_ _0402_ _0406_ VGND VGND VPWR VPWR _0433_ sky130_fd_sc_hd__a21o_1
X_1098_ net191 net117 VGND VGND VPWR VPWR _0231_ sky130_fd_sc_hd__nor2_1
X_1167_ net211 _0297_ VGND VGND VPWR VPWR _0299_ sky130_fd_sc_hd__or2_1
XTAP_TAPCELL_ROW_30_281 VGND VPWR sky130_fd_sc_hd__tapvpwrvgnd_1
XFILLER_20_253 VPWR VGND VPWR VGND sky130_ef_sc_hd__decap_12
XTAP_TAPCELL_ROW_22_237 VGND VPWR sky130_fd_sc_hd__tapvpwrvgnd_1
XFILLER_18_53 VPWR VGND VPWR VGND sky130_ef_sc_hd__decap_12
XFILLER_34_85 VGND VGND VPWR VPWR sky130_fd_sc_hd__decap_3
XFILLER_34_41 VGND VGND VPWR VPWR sky130_fd_sc_hd__fill_2
XFILLER_38_128 VGND VGND VPWR VPWR sky130_fd_sc_hd__fill_1
XFILLER_19_320 VGND VGND VPWR VPWR sky130_fd_sc_hd__fill_2
X_1021_ net216 VGND VGND VPWR VPWR _0110_ sky130_fd_sc_hd__inv_2
X_1785_ _0895_ _0802_ net204 VGND VGND VPWR VPWR _0896_ sky130_fd_sc_hd__mux2_1
X_1923_ net125 _0006_ net124 _0000_ VGND VGND VPWR VPWR _0013_ sky130_fd_sc_hd__a2bb2o_4
X_1854_ _0175_ _0960_ _0961_ VGND VGND VPWR VPWR _0962_ sky130_fd_sc_hd__o21ai_1
X_1219_ net238 net198 VGND VGND VPWR VPWR _0350_ sky130_fd_sc_hd__and2_1
XFILLER_20_54 VPWR VGND VPWR VGND sky130_ef_sc_hd__decap_12
XFILLER_45_95 VGND VGND VPWR VPWR sky130_fd_sc_hd__fill_1
XFILLER_45_51 VGND VGND VPWR VPWR sky130_fd_sc_hd__decap_4
XFILLER_43_175 VGND VGND VPWR VPWR sky130_fd_sc_hd__fill_1
XFILLER_31_304 VGND VGND VPWR VPWR sky130_fd_sc_hd__decap_4
XFILLER_28_183 VGND VGND VPWR VPWR sky130_fd_sc_hd__fill_2
XTAP_TAPCELL_ROW_41_343 VGND VPWR sky130_fd_sc_hd__tapvpwrvgnd_1
X_1570_ _0165_ _0664_ _0665_ _0661_ VGND VGND VPWR VPWR _0689_ sky130_fd_sc_hd__a2bb2o_4
X_2053_ _0112_ _0146_ VGND VGND VPWR VPWR _0147_ sky130_fd_sc_hd__xnor2_1
XFILLER_26_109 VGND VGND VPWR VPWR sky130_fd_sc_hd__decap_6
XFILLER_13_3 VPWR VGND VPWR VGND sky130_ef_sc_hd__decap_12
Xrebuffer28 _0767_ VGND VGND VPWR VPWR net280 sky130_fd_sc_hd__dlygate4sd1_1
XFILLER_34_197 VPWR VGND VPWR VGND sky130_ef_sc_hd__decap_12
XFILLER_34_175 VGND VGND VPWR VPWR sky130_fd_sc_hd__fill_2
XFILLER_34_164 VGND VGND VPWR VPWR sky130_fd_sc_hd__fill_2
X_1768_ net248 net46 VGND VGND VPWR VPWR _0880_ sky130_fd_sc_hd__nand2_1
X_1837_ net245 net119 _0943_ _0945_ net129 VGND VGND VPWR VPWR _0946_ sky130_fd_sc_hd__o221a_1
X_1906_ net241 _1010_ net157 VGND VGND VPWR VPWR _1012_ sky130_fd_sc_hd__o21a_1
X_1699_ _0800_ net124 _0813_ VGND VGND VPWR VPWR net82 sky130_fd_sc_hd__a21o_1
XFILLER_13_304 VGND VGND VPWR VPWR sky130_fd_sc_hd__fill_1
XFILLER_40_112 VGND VGND VPWR VPWR sky130_fd_sc_hd__fill_2
XFILLER_15_76 VGND VGND VPWR VPWR sky130_fd_sc_hd__decap_3
Xoutput75 net75 VGND VGND VPWR VPWR Result[11] sky130_fd_sc_hd__buf_6
Xoutput97 net97 VGND VGND VPWR VPWR Result[31] sky130_fd_sc_hd__buf_6
Xoutput86 net86 VGND VGND VPWR VPWR Result[21] sky130_fd_sc_hd__buf_6
XFILLER_0_285 VGND VGND VPWR VPWR sky130_fd_sc_hd__decap_3
X_1622_ net107 _0739_ net184 VGND VGND VPWR VPWR _0740_ sky130_fd_sc_hd__o21ai_1
XFILLER_39_223 VGND VGND VPWR VPWR sky130_fd_sc_hd__fill_1
X_1553_ net115 _0662_ _0672_ VGND VGND VPWR VPWR _0673_ sky130_fd_sc_hd__a21bo_1
X_1484_ _0590_ net124 _0606_ net184 _0597_ VGND VGND VPWR VPWR _0607_ sky130_fd_sc_hd__a221o_1
XFILLER_39_267 VGND VGND VPWR VPWR sky130_fd_sc_hd__decap_6
X_2036_ _0497_ _0527_ _0127_ VGND VGND VPWR VPWR _0128_ sky130_fd_sc_hd__o21a_1
XFILLER_22_167 VPWR VGND VPWR VGND sky130_ef_sc_hd__decap_12
XFILLER_42_41 VPWR VGND VPWR VGND sky130_ef_sc_hd__decap_12
Xrebuffer8 net275 VGND VGND VPWR VPWR net260 sky130_fd_sc_hd__clkbuf_2
XFILLER_3_57 VGND VGND VPWR VPWR sky130_fd_sc_hd__decap_8
XTAP_TAPCELL_ROW_8_160 VGND VPWR sky130_fd_sc_hd__tapvpwrvgnd_1
XFILLER_36_204 VPWR VGND VPWR VGND sky130_ef_sc_hd__decap_12
XTAP_TAPCELL_ROW_14_195 VGND VPWR sky130_fd_sc_hd__tapvpwrvgnd_1
X_1536_ _0420_ _0656_ net174 VGND VGND VPWR VPWR _0657_ sky130_fd_sc_hd__mux2_1
X_1605_ _0721_ _0722_ net123 VGND VGND VPWR VPWR _0723_ sky130_fd_sc_hd__a21o_1
XFILLER_8_171 VGND VGND VPWR VPWR sky130_fd_sc_hd__fill_2
Xfanout117 _0189_ VGND VGND VPWR VPWR net117 sky130_fd_sc_hd__buf_8
Xfanout128 _0209_ VGND VGND VPWR VPWR net128 sky130_fd_sc_hd__buf_2
X_1398_ net135 _0519_ _0521_ net142 VGND VGND VPWR VPWR _0524_ sky130_fd_sc_hd__a22oi_1
Xfanout139 net141 VGND VGND VPWR VPWR net139 sky130_fd_sc_hd__buf_2
X_1467_ _0588_ _0589_ VGND VGND VPWR VPWR _0590_ sky130_fd_sc_hd__nand2_2
XFILLER_50_251 VGND VGND VPWR VPWR sky130_fd_sc_hd__fill_1
X_2019_ net96 net71 VGND VGND VPWR VPWR _0109_ sky130_fd_sc_hd__xnor2_2
XFILLER_42_229 VGND VGND VPWR VPWR sky130_fd_sc_hd__fill_1
XFILLER_27_259 VPWR VGND VPWR VGND sky130_ef_sc_hd__decap_12
XPHY_EDGE_ROW_19_Left_73 VGND VGND VPWR VPWR sky130_fd_sc_hd__decap_3
XFILLER_50_284 VPWR VGND VPWR VGND sky130_ef_sc_hd__decap_12
XFILLER_37_63 VGND VGND VPWR VPWR sky130_fd_sc_hd__decap_6
XTAP_TAPCELL_ROW_5_141 VGND VPWR sky130_fd_sc_hd__tapvpwrvgnd_1
XFILLER_53_51 VGND VGND VPWR VPWR sky130_fd_sc_hd__decap_4
XFILLER_41_262 VGND VGND VPWR VPWR sky130_fd_sc_hd__decap_4
XFILLER_5_152 VPWR VGND VPWR VGND sky130_ef_sc_hd__decap_12
XTAP_TAPCELL_ROW_11_176 VGND VPWR sky130_fd_sc_hd__tapvpwrvgnd_1
X_1252_ net229 net215 net207 net6 net219 net210 VGND VGND VPWR VPWR _0382_ sky130_fd_sc_hd__mux4_1
X_1321_ _0307_ _0280_ net203 VGND VGND VPWR VPWR _0449_ sky130_fd_sc_hd__mux2_1
X_1183_ net198 net148 VGND VGND VPWR VPWR _0314_ sky130_fd_sc_hd__nand2_1
XFILLER_17_281 VPWR VGND VPWR VGND sky130_ef_sc_hd__decap_12
XTAP_TAPCELL_ROW_19_221 VGND VPWR sky130_fd_sc_hd__tapvpwrvgnd_1
X_1519_ _0638_ _0639_ VGND VGND VPWR VPWR _0640_ sky130_fd_sc_hd__nor2_1
XPHY_EDGE_ROW_12_Right_12 VGND VGND VPWR VPWR sky130_fd_sc_hd__decap_3
XPHY_EDGE_ROW_21_Right_21 VGND VGND VPWR VPWR sky130_fd_sc_hd__decap_3
XPHY_EDGE_ROW_4_Left_58 VGND VGND VPWR VPWR sky130_fd_sc_hd__decap_3
XFILLER_23_54 VGND VGND VPWR VPWR sky130_fd_sc_hd__fill_2
XFILLER_23_262 VPWR VGND VPWR VGND sky130_ef_sc_hd__decap_12
XPHY_EDGE_ROW_30_Right_30 VGND VGND VPWR VPWR sky130_fd_sc_hd__decap_3
XFILLER_0_47 VGND VGND VPWR VPWR sky130_fd_sc_hd__fill_1
XTAP_TAPCELL_ROW_16_202 VGND VPWR sky130_fd_sc_hd__tapvpwrvgnd_1
X_1870_ net175 _0779_ _0977_ net114 VGND VGND VPWR VPWR _0978_ sky130_fd_sc_hd__o211a_1
XFILLER_14_251 VGND VGND VPWR VPWR sky130_fd_sc_hd__fill_1
XFILLER_14_273 VGND VGND VPWR VPWR sky130_fd_sc_hd__decap_3
XFILLER_43_3 VPWR VGND VPWR VGND sky130_ef_sc_hd__decap_12
XFILLER_37_321 VGND VGND VPWR VPWR sky130_fd_sc_hd__fill_1
X_1166_ net211 _0297_ VGND VGND VPWR VPWR _0298_ sky130_fd_sc_hd__nor2_1
X_1304_ net169 _0432_ VGND VGND VPWR VPWR net99 sky130_fd_sc_hd__nor2_1
X_1235_ _0356_ _0364_ VGND VGND VPWR VPWR _0365_ sky130_fd_sc_hd__xnor2_1
X_1097_ _0227_ _0229_ net200 VGND VGND VPWR VPWR _0230_ sky130_fd_sc_hd__mux2_1
XTAP_TAPCELL_ROW_22_238 VGND VPWR sky130_fd_sc_hd__tapvpwrvgnd_1
X_1999_ net57 net150 net145 _0087_ VGND VGND VPWR VPWR _0088_ sky130_fd_sc_hd__a211o_1
XTAP_TAPCELL_ROW_30_282 VGND VPWR sky130_fd_sc_hd__tapvpwrvgnd_1
XFILLER_20_265 VPWR VGND VPWR VGND sky130_ef_sc_hd__decap_12
XFILLER_47_129 VGND VGND VPWR VPWR sky130_fd_sc_hd__fill_1
XFILLER_18_65 VGND VGND VPWR VPWR sky130_fd_sc_hd__fill_2
XFILLER_50_41 VPWR VGND VPWR VGND sky130_ef_sc_hd__decap_12
XFILLER_34_64 VGND VGND VPWR VPWR sky130_fd_sc_hd__decap_4
XFILLER_7_258 VGND VGND VPWR VPWR sky130_fd_sc_hd__decap_3
X_1020_ net250 VGND VGND VPWR VPWR _0100_ sky130_fd_sc_hd__inv_2
XFILLER_46_195 VGND VGND VPWR VPWR sky130_fd_sc_hd__fill_1
X_1922_ _0548_ _0010_ _0011_ net257 VGND VGND VPWR VPWR _0012_ sky130_fd_sc_hd__o31a_1
X_1784_ _0855_ _0894_ net179 VGND VGND VPWR VPWR _0895_ sky130_fd_sc_hd__mux2_1
X_1853_ net244 _0959_ net155 VGND VGND VPWR VPWR _0961_ sky130_fd_sc_hd__o21a_1
X_1149_ net14 net247 net246 net245 net336 net212 VGND VGND VPWR VPWR _0281_ sky130_fd_sc_hd__mux4_1
XFILLER_29_129 VGND VGND VPWR VPWR sky130_fd_sc_hd__decap_4
X_1218_ net238 net198 VGND VGND VPWR VPWR _0349_ sky130_fd_sc_hd__nor2_1
XTAP_TAPCELL_ROW_50_388 VGND VPWR sky130_fd_sc_hd__tapvpwrvgnd_1
XFILLER_28_195 VGND VGND VPWR VPWR sky130_fd_sc_hd__fill_1
XPHY_EDGE_ROW_7_Left_61 VGND VGND VPWR VPWR sky130_fd_sc_hd__decap_3
XFILLER_6_79 VGND VGND VPWR VPWR sky130_fd_sc_hd__fill_1
X_2052_ _0114_ _0145_ VGND VGND VPWR VPWR _0146_ sky130_fd_sc_hd__xnor2_1
Xrebuffer29 _0862_ VGND VGND VPWR VPWR net281 sky130_fd_sc_hd__dlygate4sd1_1
X_1905_ net157 _1010_ VGND VGND VPWR VPWR _1011_ sky130_fd_sc_hd__nand2_1
X_1767_ net248 net119 _0878_ net163 VGND VGND VPWR VPWR _0879_ sky130_fd_sc_hd__o22a_1
XPHY_EDGE_ROW_6_Right_6 VGND VGND VPWR VPWR sky130_fd_sc_hd__decap_3
X_1836_ net245 net49 net144 VGND VGND VPWR VPWR _0945_ sky130_fd_sc_hd__a21oi_1
X_1698_ _0812_ net125 _0248_ _0806_ VGND VGND VPWR VPWR _0813_ sky130_fd_sc_hd__a2bb2o_1
XFILLER_25_165 VGND VGND VPWR VPWR sky130_fd_sc_hd__decap_3
Xoutput87 net87 VGND VGND VPWR VPWR Result[22] sky130_fd_sc_hd__buf_6
XPHY_EDGE_ROW_33_Left_87 VGND VGND VPWR VPWR sky130_fd_sc_hd__decap_3
XFILLER_0_253 VGND VGND VPWR VPWR sky130_fd_sc_hd__decap_4
XFILLER_0_242 VGND VGND VPWR VPWR sky130_fd_sc_hd__decap_6
Xoutput98 net98 VGND VGND VPWR VPWR Result[3] sky130_fd_sc_hd__clkbuf_4
Xoutput76 net76 VGND VGND VPWR VPWR Result[12] sky130_fd_sc_hd__clkbuf_4
X_1621_ net191 net167 _0737_ _0738_ VGND VGND VPWR VPWR _0739_ sky130_fd_sc_hd__a31o_1
X_1552_ _0670_ _0671_ VGND VGND VPWR VPWR _0672_ sky130_fd_sc_hd__nand2_1
XFILLER_39_235 VGND VGND VPWR VPWR sky130_fd_sc_hd__decap_8
X_1483_ net113 _0604_ _0605_ net190 _0600_ VGND VGND VPWR VPWR _0606_ sky130_fd_sc_hd__a221o_1
X_2035_ net101 net102 VGND VGND VPWR VPWR _0127_ sky130_fd_sc_hd__or2_1
XFILLER_22_179 VGND VGND VPWR VPWR sky130_fd_sc_hd__decap_4
X_1819_ net246 net119 net130 _0923_ _0928_ VGND VGND VPWR VPWR _0929_ sky130_fd_sc_hd__o221a_1
XFILLER_38_290 VGND VGND VPWR VPWR sky130_fd_sc_hd__fill_1
XFILLER_53_271 VGND VGND VPWR VPWR sky130_fd_sc_hd__fill_2
XFILLER_42_53 VGND VGND VPWR VPWR sky130_fd_sc_hd__decap_8
XFILLER_26_65 VPWR VGND VPWR VGND sky130_ef_sc_hd__decap_12
XFILLER_9_106 VGND VGND VPWR VPWR sky130_fd_sc_hd__fill_1
XFILLER_13_157 VGND VGND VPWR VPWR sky130_fd_sc_hd__decap_4
XTAP_TAPCELL_ROW_8_161 VGND VPWR sky130_fd_sc_hd__tapvpwrvgnd_1
XFILLER_44_271 VPWR VGND VPWR VGND sky130_ef_sc_hd__decap_12
XFILLER_36_216 VGND VGND VPWR VPWR sky130_fd_sc_hd__fill_1
X_1535_ _0655_ _0543_ net201 VGND VGND VPWR VPWR _0656_ sky130_fd_sc_hd__mux2_1
Xfanout107 _0548_ VGND VGND VPWR VPWR net107 sky130_fd_sc_hd__buf_2
X_1604_ net39 net137 net129 _0167_ VGND VGND VPWR VPWR _0722_ sky130_fd_sc_hd__o2bb2a_1
Xfanout129 net130 VGND VGND VPWR VPWR net129 sky130_fd_sc_hd__buf_2
Xfanout118 net121 VGND VGND VPWR VPWR net118 sky130_fd_sc_hd__buf_2
X_1397_ net127 _0520_ VGND VGND VPWR VPWR _0523_ sky130_fd_sc_hd__or2_1
X_1466_ net34 net135 net128 _0163_ VGND VGND VPWR VPWR _0589_ sky130_fd_sc_hd__o2bb2a_1
XFILLER_50_241 VGND VGND VPWR VPWR sky130_fd_sc_hd__fill_1
X_2018_ net96 net71 VGND VGND VPWR VPWR _0108_ sky130_fd_sc_hd__nor2_1
XFILLER_10_105 VGND VGND VPWR VPWR sky130_fd_sc_hd__fill_1
XFILLER_50_296 VPWR VGND VPWR VGND sky130_ef_sc_hd__decap_12
XFILLER_12_12 VPWR VGND VPWR VGND sky130_ef_sc_hd__decap_12
XTAP_TAPCELL_ROW_5_142 VGND VPWR sky130_fd_sc_hd__tapvpwrvgnd_1
XFILLER_33_219 VGND VGND VPWR VPWR sky130_fd_sc_hd__decap_4
XFILLER_26_260 VGND VGND VPWR VPWR sky130_fd_sc_hd__decap_4
XFILLER_53_85 VGND VGND VPWR VPWR sky130_fd_sc_hd__decap_3
XFILLER_53_41 VGND VGND VPWR VPWR sky130_fd_sc_hd__decap_6
XFILLER_41_285 VGND VGND VPWR VPWR sky130_fd_sc_hd__fill_1
XPHY_EDGE_ROW_36_Left_90 VGND VGND VPWR VPWR sky130_fd_sc_hd__decap_3
X_1320_ net120 _0447_ _0445_ VGND VGND VPWR VPWR _0448_ sky130_fd_sc_hd__o21ai_1
XFILLER_5_164 VGND VGND VPWR VPWR sky130_fd_sc_hd__decap_4
XTAP_TAPCELL_ROW_11_177 VGND VPWR sky130_fd_sc_hd__tapvpwrvgnd_1
X_1251_ net173 _0190_ _0380_ _0376_ VGND VGND VPWR VPWR _0381_ sky130_fd_sc_hd__a31oi_2
X_1182_ _0100_ _0267_ _0264_ _0268_ VGND VGND VPWR VPWR _0313_ sky130_fd_sc_hd__a2bb2o_4
XTAP_TAPCELL_ROW_19_222 VGND VPWR sky130_fd_sc_hd__tapvpwrvgnd_1
XFILLER_17_293 VGND VGND VPWR VPWR sky130_fd_sc_hd__decap_6
XPHY_EDGE_ROW_20_Left_74 VGND VGND VPWR VPWR sky130_fd_sc_hd__decap_3
XFILLER_24_208 VGND VGND VPWR VPWR sky130_fd_sc_hd__decap_3
XFILLER_32_296 VGND VGND VPWR VPWR sky130_fd_sc_hd__fill_1
X_1449_ net226 net31 net217 VGND VGND VPWR VPWR _0573_ sky130_fd_sc_hd__mux2_1
X_1518_ net215 net152 _0637_ VGND VGND VPWR VPWR _0639_ sky130_fd_sc_hd__and3_1
XFILLER_23_274 VGND VGND VPWR VPWR sky130_fd_sc_hd__decap_6
XFILLER_3_3 VPWR VGND VPWR VGND sky130_ef_sc_hd__decap_12
XFILLER_48_85 VPWR VGND VPWR VGND sky130_ef_sc_hd__decap_12
XFILLER_48_74 VGND VGND VPWR VPWR sky130_fd_sc_hd__fill_1
XFILLER_48_41 VPWR VGND VPWR VGND sky130_ef_sc_hd__decap_12
XTAP_TAPCELL_ROW_16_203 VGND VPWR sky130_fd_sc_hd__tapvpwrvgnd_1
XFILLER_9_57 VGND VGND VPWR VPWR sky130_fd_sc_hd__decap_4
X_1303_ _0248_ _0417_ _0424_ _0431_ _0412_ VGND VGND VPWR VPWR _0432_ sky130_fd_sc_hd__a311oi_4
X_1096_ net215 net207 net189 net183 net219 net210 VGND VGND VPWR VPWR _0229_ sky130_fd_sc_hd__mux4_1
XFILLER_49_160 VGND VGND VPWR VPWR sky130_fd_sc_hd__fill_1
XTAP_TAPCELL_ROW_47_372 VGND VPWR sky130_fd_sc_hd__tapvpwrvgnd_1
XTAP_TAPCELL_ROW_39_328 VGND VPWR sky130_fd_sc_hd__tapvpwrvgnd_1
X_1165_ _0100_ net216 _0252_ VGND VGND VPWR VPWR _0297_ sky130_fd_sc_hd__o21a_1
X_1234_ net233 _0357_ _0362_ VGND VGND VPWR VPWR _0364_ sky130_fd_sc_hd__mux2_1
XFILLER_20_211 VGND VGND VPWR VPWR sky130_fd_sc_hd__decap_4
XFILLER_20_244 VGND VGND VPWR VPWR sky130_fd_sc_hd__decap_8
XTAP_TAPCELL_ROW_22_239 VGND VPWR sky130_fd_sc_hd__tapvpwrvgnd_1
X_1998_ net57 net164 VGND VGND VPWR VPWR _0087_ sky130_fd_sc_hd__nor2_1
XTAP_TAPCELL_ROW_30_283 VGND VPWR sky130_fd_sc_hd__tapvpwrvgnd_1
XFILLER_20_277 VPWR VGND VPWR VGND sky130_ef_sc_hd__decap_12
XFILLER_28_300 VGND VGND VPWR VPWR sky130_fd_sc_hd__fill_1
XFILLER_50_53 VGND VGND VPWR VPWR sky130_fd_sc_hd__decap_6
X_1921_ net182 _0626_ _0631_ net112 VGND VGND VPWR VPWR _0011_ sky130_fd_sc_hd__a22o_1
X_1852_ net155 _0959_ VGND VGND VPWR VPWR _0960_ sky130_fd_sc_hd__nand2_1
X_1783_ net15 net14 net223 VGND VGND VPWR VPWR _0894_ sky130_fd_sc_hd__mux2_1
X_1148_ net9 net10 net251 net249 net220 net213 VGND VGND VPWR VPWR _0280_ sky130_fd_sc_hd__mux4_1
X_1079_ net252 net251 net220 VGND VGND VPWR VPWR _0212_ sky130_fd_sc_hd__mux2_1
X_1217_ net181 _0332_ _0347_ _0248_ VGND VGND VPWR VPWR _0348_ sky130_fd_sc_hd__o211a_1
XTAP_TAPCELL_ROW_50_389 VGND VPWR sky130_fd_sc_hd__tapvpwrvgnd_1
XFILLER_29_54 VGND VGND VPWR VPWR sky130_fd_sc_hd__fill_2
XPHY_EDGE_ROW_51_Left_105 VGND VGND VPWR VPWR sky130_fd_sc_hd__decap_3
XFILLER_43_111 VGND VGND VPWR VPWR sky130_fd_sc_hd__fill_1
XFILLER_3_273 VGND VGND VPWR VPWR sky130_fd_sc_hd__fill_1
XFILLER_3_251 VGND VGND VPWR VPWR sky130_fd_sc_hd__fill_2
X_2051_ _0116_ _0144_ VGND VGND VPWR VPWR _0145_ sky130_fd_sc_hd__xnor2_1
XFILLER_34_155 VGND VGND VPWR VPWR sky130_fd_sc_hd__fill_1
XFILLER_34_122 VPWR VGND VPWR VGND sky130_ef_sc_hd__decap_12
X_1835_ net163 net110 _0943_ VGND VGND VPWR VPWR _0944_ sky130_fd_sc_hd__mux2_1
X_1904_ net52 net150 net145 _1009_ VGND VGND VPWR VPWR _1010_ sky130_fd_sc_hd__a211o_1
X_1766_ net248 net46 VGND VGND VPWR VPWR _0878_ sky130_fd_sc_hd__nor2_1
X_1697_ net252 net119 _0810_ _0811_ VGND VGND VPWR VPWR _0812_ sky130_fd_sc_hd__o211a_1
XFILLER_25_177 VGND VGND VPWR VPWR sky130_fd_sc_hd__fill_1
XFILLER_25_111 VGND VGND VPWR VPWR sky130_fd_sc_hd__fill_1
XFILLER_31_55 VGND VGND VPWR VPWR sky130_fd_sc_hd__fill_1
Xoutput88 net88 VGND VGND VPWR VPWR Result[23] sky130_fd_sc_hd__buf_6
Xoutput77 net77 VGND VGND VPWR VPWR Result[13] sky130_fd_sc_hd__buf_6
Xoutput99 net99 VGND VGND VPWR VPWR Result[4] sky130_fd_sc_hd__buf_2
XFILLER_31_169 VGND VGND VPWR VPWR sky130_fd_sc_hd__fill_1
XFILLER_31_158 VGND VGND VPWR VPWR sky130_fd_sc_hd__decap_4
X_1620_ _0231_ _0732_ _0736_ net114 VGND VGND VPWR VPWR _0738_ sky130_fd_sc_hd__a22o_1
X_1482_ _0329_ _0598_ _0515_ VGND VGND VPWR VPWR _0605_ sky130_fd_sc_hd__a21bo_1
X_1551_ net207 net37 VGND VGND VPWR VPWR _0671_ sky130_fd_sc_hd__nand2_1
X_2034_ _0580_ net104 _0553_ VGND VGND VPWR VPWR _0126_ sky130_fd_sc_hd__mux2_1
XFILLER_10_309 VGND VGND VPWR VPWR sky130_fd_sc_hd__decap_3
X_1818_ net164 _0924_ VGND VGND VPWR VPWR _0928_ sky130_fd_sc_hd__or2_1
X_1749_ _0846_ net124 _0854_ _0861_ VGND VGND VPWR VPWR net85 sky130_fd_sc_hd__a211o_4
XFILLER_45_239 VGND VGND VPWR VPWR sky130_fd_sc_hd__decap_6
XFILLER_13_125 VGND VGND VPWR VPWR sky130_fd_sc_hd__fill_1
XFILLER_21_180 VGND VGND VPWR VPWR sky130_fd_sc_hd__fill_1
XFILLER_3_15 VPWR VGND VPWR VGND sky130_ef_sc_hd__decap_12
XTAP_TAPCELL_ROW_8_162 VGND VPWR sky130_fd_sc_hd__tapvpwrvgnd_1
XFILLER_44_283 VPWR VGND VPWR VGND sky130_ef_sc_hd__decap_12
X_1534_ _0601_ _0654_ net180 VGND VGND VPWR VPWR _0655_ sky130_fd_sc_hd__mux2_1
X_1603_ net258 _0720_ VGND VGND VPWR VPWR _0721_ sky130_fd_sc_hd__xor2_1
X_1465_ _0587_ net330 VGND VGND VPWR VPWR _0588_ sky130_fd_sc_hd__xnor2_2
Xfanout108 _0260_ VGND VGND VPWR VPWR net108 sky130_fd_sc_hd__clkbuf_4
Xfanout119 net121 VGND VGND VPWR VPWR net119 sky130_fd_sc_hd__clkbuf_4
X_2017_ _0094_ _0410_ _0101_ _0107_ VGND VGND VPWR VPWR net71 sky130_fd_sc_hd__a211o_4
X_1396_ net115 _0499_ _0521_ VGND VGND VPWR VPWR _0522_ sky130_fd_sc_hd__a21o_1
XFILLER_50_253 VGND VGND VPWR VPWR sky130_fd_sc_hd__decap_8
XFILLER_35_294 VGND VGND VPWR VPWR sky130_fd_sc_hd__fill_2
XFILLER_10_128 VGND VGND VPWR VPWR sky130_fd_sc_hd__decap_3
XFILLER_2_305 VGND VGND VPWR VPWR sky130_fd_sc_hd__decap_3
XFILLER_12_24 VGND VGND VPWR VPWR sky130_fd_sc_hd__decap_4
XFILLER_12_57 VGND VGND VPWR VPWR sky130_fd_sc_hd__fill_1
XTAP_TAPCELL_ROW_5_143 VGND VPWR sky130_fd_sc_hd__tapvpwrvgnd_1
XTAP_TAPCELL_ROW_28_267 VGND VPWR sky130_fd_sc_hd__tapvpwrvgnd_1
XFILLER_5_110 VGND VGND VPWR VPWR sky130_fd_sc_hd__fill_2
XTAP_TAPCELL_ROW_11_178 VGND VPWR sky130_fd_sc_hd__tapvpwrvgnd_1
X_1250_ _0378_ _0379_ net204 VGND VGND VPWR VPWR _0380_ sky130_fd_sc_hd__mux2_1
X_1181_ _0278_ _0312_ VGND VGND VPWR VPWR net84 sky130_fd_sc_hd__nand2_2
XFILLER_32_286 VGND VGND VPWR VPWR sky130_fd_sc_hd__fill_1
X_1448_ _0282_ _0308_ net176 VGND VGND VPWR VPWR _0572_ sky130_fd_sc_hd__mux2_1
X_1517_ net215 _0637_ net152 VGND VGND VPWR VPWR _0638_ sky130_fd_sc_hd__o21ai_1
XTAP_TAPCELL_ROW_2_124 VGND VPWR sky130_fd_sc_hd__tapvpwrvgnd_1
X_1379_ net62 net135 net127 _0160_ VGND VGND VPWR VPWR _0505_ sky130_fd_sc_hd__o2bb2a_1
XFILLER_48_97 VGND VGND VPWR VPWR sky130_fd_sc_hd__decap_3
XFILLER_48_53 VGND VGND VPWR VPWR sky130_fd_sc_hd__decap_8
XFILLER_46_312 VGND VGND VPWR VPWR sky130_fd_sc_hd__fill_1
XFILLER_0_27 VGND VGND VPWR VPWR sky130_fd_sc_hd__fill_1
XFILLER_9_69 VGND VGND VPWR VPWR sky130_fd_sc_hd__decap_4
XFILLER_14_253 VGND VGND VPWR VPWR sky130_fd_sc_hd__fill_2
XTAP_TAPCELL_ROW_16_204 VGND VPWR sky130_fd_sc_hd__tapvpwrvgnd_1
XFILLER_49_150 VGND VGND VPWR VPWR sky130_fd_sc_hd__fill_1
XFILLER_29_3 VPWR VGND VPWR VGND sky130_ef_sc_hd__decap_12
X_1302_ _0427_ _0428_ _0430_ net68 VGND VGND VPWR VPWR _0431_ sky130_fd_sc_hd__o31a_1
X_1233_ _0357_ _0362_ VGND VGND VPWR VPWR _0363_ sky130_fd_sc_hd__nand2_1
X_1095_ net189 net183 net220 VGND VGND VPWR VPWR _0228_ sky130_fd_sc_hd__mux2_1
XTAP_TAPCELL_ROW_47_373 VGND VPWR sky130_fd_sc_hd__tapvpwrvgnd_1
XTAP_TAPCELL_ROW_39_329 VGND VPWR sky130_fd_sc_hd__tapvpwrvgnd_1
X_1164_ net182 net150 VGND VGND VPWR VPWR _0296_ sky130_fd_sc_hd__nand2_1
X_1997_ _0067_ _0062_ _0066_ VGND VGND VPWR VPWR _0086_ sky130_fd_sc_hd__a21oi_4
XFILLER_20_289 VPWR VGND VPWR VGND sky130_ef_sc_hd__decap_12
XFILLER_11_256 VPWR VGND VPWR VGND sky130_ef_sc_hd__decap_12
XFILLER_46_197 VGND VGND VPWR VPWR sky130_fd_sc_hd__decap_6
X_1920_ net175 _0826_ _0009_ net114 VGND VGND VPWR VPWR _0010_ sky130_fd_sc_hd__o211a_1
X_1851_ net50 net150 net145 _0958_ VGND VGND VPWR VPWR _0959_ sky130_fd_sc_hd__a211o_1
X_1782_ _0892_ _0891_ VGND VGND VPWR VPWR _0893_ sky130_fd_sc_hd__nand2_2
X_1216_ _0190_ _0339_ _0346_ _0225_ VGND VGND VPWR VPWR _0347_ sky130_fd_sc_hd__a211o_1
X_1078_ net8 net9 net220 VGND VGND VPWR VPWR _0211_ sky130_fd_sc_hd__mux2_2
X_1147_ net9 net252 net220 VGND VGND VPWR VPWR _0279_ sky130_fd_sc_hd__mux2_1
XFILLER_37_164 VGND VGND VPWR VPWR sky130_fd_sc_hd__decap_4
XTAP_TAPCELL_ROW_35_310 VGND VPWR sky130_fd_sc_hd__tapvpwrvgnd_1
XFILLER_1_81 VGND VGND VPWR VPWR sky130_fd_sc_hd__decap_8
XFILLER_28_175 VGND VGND VPWR VPWR sky130_fd_sc_hd__decap_8
XFILLER_28_120 VGND VGND VPWR VPWR sky130_fd_sc_hd__fill_1
XFILLER_43_167 VGND VGND VPWR VPWR sky130_fd_sc_hd__fill_1
XFILLER_31_318 VGND VGND VPWR VPWR sky130_fd_sc_hd__decap_4
X_2050_ _0117_ _0142_ VGND VGND VPWR VPWR _0144_ sky130_fd_sc_hd__xnor2_1
XFILLER_34_134 VGND VGND VPWR VPWR sky130_fd_sc_hd__decap_6
XFILLER_34_101 VPWR VGND VPWR VGND sky130_ef_sc_hd__decap_12
XFILLER_19_175 VGND VGND VPWR VPWR sky130_fd_sc_hd__decap_6
X_1765_ net181 _0448_ _0876_ VGND VGND VPWR VPWR _0877_ sky130_fd_sc_hd__a21oi_1
X_1834_ net245 net49 VGND VGND VPWR VPWR _0943_ sky130_fd_sc_hd__nor2_1
X_1903_ net52 net164 VGND VGND VPWR VPWR _1009_ sky130_fd_sc_hd__nor2_1
X_1696_ net165 net109 _0807_ VGND VGND VPWR VPWR _0811_ sky130_fd_sc_hd__mux2_1
XFILLER_40_148 VGND VGND VPWR VPWR sky130_fd_sc_hd__decap_4
XFILLER_15_57 VGND VGND VPWR VPWR sky130_fd_sc_hd__decap_4
Xoutput89 net89 VGND VGND VPWR VPWR Result[24] sky130_fd_sc_hd__buf_8
Xoutput78 net78 VGND VGND VPWR VPWR Result[14] sky130_fd_sc_hd__buf_6
XFILLER_0_222 VGND VGND VPWR VPWR sky130_fd_sc_hd__fill_2
XFILLER_0_211 VGND VGND VPWR VPWR sky130_fd_sc_hd__decap_6
XFILLER_16_178 VGND VGND VPWR VPWR sky130_fd_sc_hd__decap_3
XFILLER_31_137 VPWR VGND VPWR VGND sky130_ef_sc_hd__decap_12
X_1481_ _0343_ _0603_ net172 VGND VGND VPWR VPWR _0604_ sky130_fd_sc_hd__mux2_1
X_1550_ net207 net37 VGND VGND VPWR VPWR _0670_ sky130_fd_sc_hd__or2_1
XFILLER_47_281 VPWR VGND VPWR VGND sky130_ef_sc_hd__decap_12
XFILLER_39_248 VPWR VGND VPWR VGND sky130_ef_sc_hd__decap_12
XFILLER_11_3 VPWR VGND VPWR VGND sky130_ef_sc_hd__decap_12
X_2033_ _0634_ net75 _0608_ VGND VGND VPWR VPWR _0125_ sky130_fd_sc_hd__mux2_1
X_1748_ net182 _0368_ _0421_ _0859_ _0248_ VGND VGND VPWR VPWR _0861_ sky130_fd_sc_hd__o311a_1
X_1817_ net140 _0925_ VGND VGND VPWR VPWR _0927_ sky130_fd_sc_hd__or2_1
X_1679_ net42 net162 VGND VGND VPWR VPWR _0794_ sky130_fd_sc_hd__nor2_1
XFILLER_53_284 VGND VGND VPWR VPWR sky130_fd_sc_hd__decap_4
XFILLER_26_45 VGND VGND VPWR VPWR sky130_fd_sc_hd__fill_1
XFILLER_3_27 VPWR VGND VPWR VGND sky130_ef_sc_hd__decap_12
XFILLER_29_281 VGND VGND VPWR VPWR sky130_fd_sc_hd__decap_4
XFILLER_44_295 VGND VGND VPWR VPWR sky130_fd_sc_hd__decap_3
X_1602_ _0167_ _0718_ _0719_ VGND VGND VPWR VPWR _0720_ sky130_fd_sc_hd__o21ai_1
XFILLER_8_141 VPWR VGND VPWR VGND sky130_ef_sc_hd__decap_12
X_1533_ net4 net3 net219 VGND VGND VPWR VPWR _0654_ sky130_fd_sc_hd__mux2_1
X_1464_ _0584_ _0586_ VGND VGND VPWR VPWR _0587_ sky130_fd_sc_hd__and2_1
X_1395_ _0519_ _0520_ VGND VGND VPWR VPWR _0521_ sky130_fd_sc_hd__nor2_1
Xfanout109 _0258_ VGND VGND VPWR VPWR net109 sky130_fd_sc_hd__buf_4
X_2016_ _0103_ _0106_ net125 VGND VGND VPWR VPWR _0107_ sky130_fd_sc_hd__a21oi_1
XFILLER_37_55 VGND VGND VPWR VPWR sky130_fd_sc_hd__fill_1
XTAP_TAPCELL_ROW_5_144 VGND VPWR sky130_fd_sc_hd__tapvpwrvgnd_1
XFILLER_53_76 VGND VGND VPWR VPWR sky130_fd_sc_hd__fill_2
XFILLER_53_32 VGND VGND VPWR VPWR sky130_fd_sc_hd__decap_6
XFILLER_53_21 VGND VGND VPWR VPWR sky130_fd_sc_hd__decap_6
XTAP_TAPCELL_ROW_28_268 VGND VPWR sky130_fd_sc_hd__tapvpwrvgnd_1
XFILLER_26_295 VGND VGND VPWR VPWR sky130_fd_sc_hd__fill_2
XFILLER_26_251 VGND VGND VPWR VPWR sky130_fd_sc_hd__fill_1
XFILLER_26_240 VGND VGND VPWR VPWR sky130_fd_sc_hd__fill_1
XFILLER_41_276 VGND VGND VPWR VPWR sky130_fd_sc_hd__decap_4
XFILLER_5_122 VGND VGND VPWR VPWR sky130_fd_sc_hd__fill_1
X_1180_ _0180_ _0271_ _0311_ _0249_ VGND VGND VPWR VPWR _0312_ sky130_fd_sc_hd__o2bb2a_1
X_1516_ net36 net147 net142 _0636_ VGND VGND VPWR VPWR _0637_ sky130_fd_sc_hd__a211o_1
X_1447_ _0293_ _0360_ _0570_ net256 VGND VGND VPWR VPWR _0571_ sky130_fd_sc_hd__a22o_1
XFILLER_4_92 VPWR VGND VPWR VGND sky130_ef_sc_hd__decap_12
XTAP_TAPCELL_ROW_2_125 VGND VPWR sky130_fd_sc_hd__tapvpwrvgnd_1
X_1378_ _0498_ _0503_ VGND VGND VPWR VPWR _0504_ sky130_fd_sc_hd__xor2_1
XFILLER_23_221 VGND VGND VPWR VPWR sky130_fd_sc_hd__decap_3
XTAP_TAPCELL_ROW_16_205 VGND VPWR sky130_fd_sc_hd__tapvpwrvgnd_1
XFILLER_9_15 VPWR VGND VPWR VGND sky130_ef_sc_hd__decap_12
XFILLER_14_232 VGND VGND VPWR VPWR sky130_fd_sc_hd__fill_1
X_1232_ net153 _0361_ VGND VGND VPWR VPWR _0362_ sky130_fd_sc_hd__nand2_1
X_1301_ net190 net232 _0429_ VGND VGND VPWR VPWR _0430_ sky130_fd_sc_hd__a21oi_1
X_1094_ net227 net225 net242 net229 net217 net208 VGND VGND VPWR VPWR _0227_ sky130_fd_sc_hd__mux4_1
XTAP_TAPCELL_ROW_47_374 VGND VPWR sky130_fd_sc_hd__tapvpwrvgnd_1
X_1163_ net191 net146 VGND VGND VPWR VPWR _0295_ sky130_fd_sc_hd__nor2_1
X_1996_ _0085_ _0077_ net169 VGND VGND VPWR VPWR net96 sky130_fd_sc_hd__a21oi_4
XFILLER_9_291 VGND VGND VPWR VPWR sky130_fd_sc_hd__fill_1
XFILLER_43_305 VGND VGND VPWR VPWR sky130_fd_sc_hd__decap_4
XFILLER_18_35 VGND VGND VPWR VPWR sky130_fd_sc_hd__fill_1
XFILLER_7_228 VGND VGND VPWR VPWR sky130_fd_sc_hd__decap_6
XFILLER_11_268 VGND VGND VPWR VPWR sky130_fd_sc_hd__decap_6
XTAP_TAPCELL_ROW_21_230 VGND VPWR sky130_fd_sc_hd__tapvpwrvgnd_1
XTAP_TAPCELL_ROW_44_355 VGND VPWR sky130_fd_sc_hd__tapvpwrvgnd_1
X_1781_ net47 net137 net129 _0173_ VGND VGND VPWR VPWR _0892_ sky130_fd_sc_hd__o2bb2a_1
X_1850_ net50 net163 VGND VGND VPWR VPWR _0958_ sky130_fd_sc_hd__nor2_1
XFILLER_41_3 VPWR VGND VPWR VGND sky130_ef_sc_hd__decap_12
XFILLER_37_132 VPWR VGND VPWR VGND sky130_ef_sc_hd__decap_12
XFILLER_37_110 VGND VGND VPWR VPWR sky130_fd_sc_hd__fill_2
X_1215_ _0343_ _0344_ VGND VGND VPWR VPWR _0346_ sky130_fd_sc_hd__and2_1
X_1146_ _0272_ _0274_ _0277_ net126 VGND VGND VPWR VPWR _0278_ sky130_fd_sc_hd__a31o_1
X_1077_ net216 net136 net133 net1 _0205_ VGND VGND VPWR VPWR _0210_ sky130_fd_sc_hd__a221o_1
X_1979_ _0065_ _0066_ VGND VGND VPWR VPWR _0067_ sky130_fd_sc_hd__nor2_1
XFILLER_4_209 VPWR VGND VPWR VGND sky130_ef_sc_hd__decap_12
XFILLER_45_55 VGND VGND VPWR VPWR sky130_fd_sc_hd__fill_1
XFILLER_43_113 VPWR VGND VPWR VGND sky130_ef_sc_hd__decap_12
XFILLER_31_308 VGND VGND VPWR VPWR sky130_fd_sc_hd__fill_1
XFILLER_28_165 VGND VGND VPWR VPWR sky130_fd_sc_hd__decap_4
XFILLER_6_27 VGND VGND VPWR VPWR sky130_fd_sc_hd__fill_1
XFILLER_19_110 VGND VGND VPWR VPWR sky130_fd_sc_hd__fill_2
XFILLER_34_113 VGND VGND VPWR VPWR sky130_fd_sc_hd__fill_2
X_1902_ _0176_ _0986_ _0987_ _0983_ VGND VGND VPWR VPWR _1008_ sky130_fd_sc_hd__a2bb2o_4
X_1764_ net192 _0452_ net107 _0875_ VGND VGND VPWR VPWR _0876_ sky130_fd_sc_hd__a211o_1
X_1833_ _0941_ _0940_ net123 VGND VGND VPWR VPWR _0942_ sky130_fd_sc_hd__a21o_1
X_1695_ net252 net42 net108 _0809_ VGND VGND VPWR VPWR _0810_ sky130_fd_sc_hd__a31o_1
X_1129_ _0252_ net108 _0259_ _0256_ VGND VGND VPWR VPWR _0262_ sky130_fd_sc_hd__o211a_1
XFILLER_31_57 VGND VGND VPWR VPWR sky130_fd_sc_hd__fill_2
Xoutput79 net79 VGND VGND VPWR VPWR Result[15] sky130_fd_sc_hd__buf_6
XFILLER_0_278 VGND VGND VPWR VPWR sky130_fd_sc_hd__fill_2
XFILLER_0_267 VGND VGND VPWR VPWR sky130_fd_sc_hd__fill_1
XPHY_EDGE_ROW_19_Right_19 VGND VGND VPWR VPWR sky130_fd_sc_hd__decap_3
X_1480_ _0602_ _0480_ net199 VGND VGND VPWR VPWR _0603_ sky130_fd_sc_hd__mux2_1
XPHY_EDGE_ROW_28_Right_28 VGND VGND VPWR VPWR sky130_fd_sc_hd__decap_3
XFILLER_47_293 VPWR VGND VPWR VGND sky130_ef_sc_hd__decap_12
XPHY_EDGE_ROW_37_Right_37 VGND VGND VPWR VPWR sky130_fd_sc_hd__decap_3
X_2032_ _0660_ _0688_ _0123_ VGND VGND VPWR VPWR _0124_ sky130_fd_sc_hd__o21a_1
XFILLER_30_171 VGND VGND VPWR VPWR sky130_fd_sc_hd__fill_2
XPHY_EDGE_ROW_46_Right_46 VGND VGND VPWR VPWR sky130_fd_sc_hd__decap_3
X_1747_ _0079_ _0368_ VGND VGND VPWR VPWR _0860_ sky130_fd_sc_hd__nor2_1
X_1678_ net252 net156 VGND VGND VPWR VPWR _0793_ sky130_fd_sc_hd__nand2_1
X_1816_ net48 net149 net116 VGND VGND VPWR VPWR _0926_ sky130_fd_sc_hd__a21bo_1
XFILLER_38_271 VGND VGND VPWR VPWR sky130_fd_sc_hd__decap_6
XFILLER_42_12 VPWR VGND VPWR VGND sky130_ef_sc_hd__decap_12
XFILLER_3_39 VPWR VGND VPWR VGND sky130_ef_sc_hd__decap_12
XPHY_EDGE_ROW_48_Left_102 VGND VGND VPWR VPWR sky130_fd_sc_hd__decap_3
X_1532_ _0413_ _0418_ _0168_ VGND VGND VPWR VPWR _0653_ sky130_fd_sc_hd__mux2_1
X_1601_ net183 _0717_ net154 VGND VGND VPWR VPWR _0719_ sky130_fd_sc_hd__o21a_1
XFILLER_8_153 VGND VGND VPWR VPWR sky130_fd_sc_hd__fill_1
XFILLER_12_193 VGND VGND VPWR VPWR sky130_fd_sc_hd__decap_3
X_1463_ _0585_ VGND VGND VPWR VPWR _0586_ sky130_fd_sc_hd__inv_2
X_1394_ net228 net62 VGND VGND VPWR VPWR _0520_ sky130_fd_sc_hd__and2_1
X_2015_ net235 net57 net108 _0105_ VGND VGND VPWR VPWR _0106_ sky130_fd_sc_hd__a31o_1
XTAP_TAPCELL_ROW_5_145 VGND VPWR sky130_fd_sc_hd__tapvpwrvgnd_1
XFILLER_53_55 VGND VGND VPWR VPWR sky130_fd_sc_hd__fill_1
XFILLER_41_266 VGND VGND VPWR VPWR sky130_fd_sc_hd__fill_1
XTAP_TAPCELL_ROW_28_269 VGND VPWR sky130_fd_sc_hd__tapvpwrvgnd_1
XFILLER_5_101 VGND VGND VPWR VPWR sky130_fd_sc_hd__fill_1
XFILLER_49_311 VGND VGND VPWR VPWR sky130_fd_sc_hd__fill_2
X_1515_ net36 net160 VGND VGND VPWR VPWR _0636_ sky130_fd_sc_hd__nor2_1
X_1446_ net234 _0288_ net173 VGND VGND VPWR VPWR _0570_ sky130_fd_sc_hd__mux2_1
XTAP_TAPCELL_ROW_2_126 VGND VPWR sky130_fd_sc_hd__tapvpwrvgnd_1
X_1377_ _0160_ _0501_ _0502_ VGND VGND VPWR VPWR _0503_ sky130_fd_sc_hd__o21ai_1
XFILLER_23_200 VGND VGND VPWR VPWR sky130_fd_sc_hd__decap_8
XFILLER_2_104 VGND VGND VPWR VPWR sky130_fd_sc_hd__fill_1
XFILLER_2_137 VGND VGND VPWR VPWR sky130_fd_sc_hd__decap_3
XTAP_TAPCELL_ROW_16_206 VGND VPWR sky130_fd_sc_hd__tapvpwrvgnd_1
XTAP_TAPCELL_ROW_24_250 VGND VPWR sky130_fd_sc_hd__tapvpwrvgnd_1
XFILLER_9_27 VPWR VGND VPWR VGND sky130_ef_sc_hd__decap_12
XPHY_EDGE_ROW_24_Left_78 VGND VGND VPWR VPWR sky130_fd_sc_hd__decap_3
XFILLER_49_130 VGND VGND VPWR VPWR sky130_fd_sc_hd__decap_6
X_1162_ _0283_ _0292_ _0289_ net255 VGND VGND VPWR VPWR _0294_ sky130_fd_sc_hd__a211oi_2
X_1231_ net143 _0358_ _0360_ VGND VGND VPWR VPWR _0361_ sky130_fd_sc_hd__or3_4
X_1300_ net145 _0425_ net132 VGND VGND VPWR VPWR _0429_ sky130_fd_sc_hd__a21oi_1
XTAP_TAPCELL_ROW_47_375 VGND VPWR sky130_fd_sc_hd__tapvpwrvgnd_1
X_1093_ net182 _0189_ VGND VGND VPWR VPWR _0226_ sky130_fd_sc_hd__or2_1
X_1995_ _0070_ net124 _0084_ _0068_ VGND VGND VPWR VPWR _0085_ sky130_fd_sc_hd__o2bb2a_4
X_1429_ _0553_ VGND VGND VPWR VPWR net103 sky130_fd_sc_hd__inv_2
XFILLER_34_68 VGND VGND VPWR VPWR sky130_fd_sc_hd__fill_1
XTAP_TAPCELL_ROW_21_231 VGND VPWR sky130_fd_sc_hd__tapvpwrvgnd_1
XFILLER_1_3 VPWR VGND VPWR VGND sky130_ef_sc_hd__decap_12
XFILLER_46_111 VGND VGND VPWR VPWR sky130_fd_sc_hd__decap_4
XTAP_TAPCELL_ROW_44_356 VGND VPWR sky130_fd_sc_hd__tapvpwrvgnd_1
X_1780_ _0885_ _0890_ VGND VGND VPWR VPWR _0891_ sky130_fd_sc_hd__xor2_1
XFILLER_34_3 VPWR VGND VPWR VGND sky130_ef_sc_hd__decap_12
XFILLER_37_188 VGND VGND VPWR VPWR sky130_fd_sc_hd__fill_1
XFILLER_37_144 VGND VGND VPWR VPWR sky130_fd_sc_hd__decap_8
X_1214_ net172 net148 VGND VGND VPWR VPWR _0345_ sky130_fd_sc_hd__nand2_1
X_1145_ net250 net121 _0273_ net161 _0276_ VGND VGND VPWR VPWR _0277_ sky130_fd_sc_hd__o221a_1
XFILLER_40_309 VGND VGND VPWR VPWR sky130_fd_sc_hd__fill_1
X_1076_ _0194_ _0195_ VGND VGND VPWR VPWR _0209_ sky130_fd_sc_hd__nand2b_1
X_1978_ net24 _0192_ _0064_ VGND VGND VPWR VPWR _0066_ sky130_fd_sc_hd__and3_1
XFILLER_20_15 VPWR VGND VPWR VGND sky130_ef_sc_hd__decap_12
XFILLER_29_57 VGND VGND VPWR VPWR sky130_fd_sc_hd__fill_1
XFILLER_43_169 VGND VGND VPWR VPWR sky130_fd_sc_hd__decap_6
XFILLER_43_125 VPWR VGND VPWR VGND sky130_ef_sc_hd__decap_12
X_1832_ net49 net138 net132 net245 VGND VGND VPWR VPWR _0941_ sky130_fd_sc_hd__a22oi_1
X_1901_ net282 _1007_ VGND VGND VPWR VPWR net91 sky130_fd_sc_hd__and2_4
XFILLER_22_309 VGND VGND VPWR VPWR sky130_fd_sc_hd__decap_4
X_1763_ net174 _0684_ _0874_ net113 VGND VGND VPWR VPWR _0875_ sky130_fd_sc_hd__o211a_1
X_1694_ net140 _0807_ _0808_ net130 VGND VGND VPWR VPWR _0809_ sky130_fd_sc_hd__o211a_1
XPHY_EDGE_ROW_27_Left_81 VGND VGND VPWR VPWR sky130_fd_sc_hd__decap_3
X_1128_ net146 net116 VGND VGND VPWR VPWR _0261_ sky130_fd_sc_hd__nand2_1
XFILLER_25_136 VGND VGND VPWR VPWR sky130_fd_sc_hd__fill_2
XPHY_EDGE_ROW_11_Left_65 VGND VGND VPWR VPWR sky130_fd_sc_hd__decap_3
XFILLER_15_15 VPWR VGND VPWR VGND sky130_ef_sc_hd__decap_12
X_1059_ net188 _0181_ VGND VGND VPWR VPWR _0192_ sky130_fd_sc_hd__nor2_2
XFILLER_40_139 VGND VGND VPWR VPWR sky130_fd_sc_hd__fill_1
XFILLER_21_320 VGND VGND VPWR VPWR sky130_fd_sc_hd__fill_2
XFILLER_0_202 VGND VGND VPWR VPWR sky130_fd_sc_hd__decap_6
XFILLER_0_257 VGND VGND VPWR VPWR sky130_fd_sc_hd__fill_1
XFILLER_16_158 VGND VGND VPWR VPWR sky130_fd_sc_hd__decap_4
XFILLER_21_91 VGND VGND VPWR VPWR sky130_fd_sc_hd__fill_1
X_2031_ net76 net77 VGND VGND VPWR VPWR _0123_ sky130_fd_sc_hd__or2_1
X_1815_ _0923_ _0924_ VGND VGND VPWR VPWR _0925_ sky130_fd_sc_hd__or2_1
X_1746_ _0858_ _0416_ VGND VGND VPWR VPWR _0859_ sky130_fd_sc_hd__nand2b_1
X_1677_ _0770_ _0767_ _0771_ VGND VGND VPWR VPWR _0792_ sky130_fd_sc_hd__a21o_1
XFILLER_53_297 VGND VGND VPWR VPWR sky130_fd_sc_hd__fill_1
XFILLER_53_264 VGND VGND VPWR VPWR sky130_fd_sc_hd__decap_4
XFILLER_53_253 VGND VGND VPWR VPWR sky130_fd_sc_hd__decap_4
XFILLER_42_24 VGND VGND VPWR VPWR sky130_fd_sc_hd__decap_4
XFILLER_21_161 VGND VGND VPWR VPWR sky130_fd_sc_hd__decap_6
X_1531_ _0377_ _0415_ _0624_ VGND VGND VPWR VPWR _0652_ sky130_fd_sc_hd__o21ai_1
XFILLER_32_90 VGND VGND VPWR VPWR sky130_fd_sc_hd__fill_2
X_1462_ net242 net152 _0583_ VGND VGND VPWR VPWR _0585_ sky130_fd_sc_hd__and3_1
X_1600_ net154 _0717_ VGND VGND VPWR VPWR _0718_ sky130_fd_sc_hd__nand2_1
XFILLER_8_176 VGND VGND VPWR VPWR sky130_fd_sc_hd__decap_8
XFILLER_27_209 VGND VGND VPWR VPWR sky130_fd_sc_hd__decap_4
X_1393_ net228 net62 VGND VGND VPWR VPWR _0519_ sky130_fd_sc_hd__nor2_1
X_2014_ net235 net120 net141 _0102_ _0104_ VGND VGND VPWR VPWR _0105_ sky130_fd_sc_hd__o221a_1
X_1729_ net249 _0840_ net155 VGND VGND VPWR VPWR _0842_ sky130_fd_sc_hd__o21a_1
XFILLER_37_57 VGND VGND VPWR VPWR sky130_fd_sc_hd__decap_3
XFILLER_53_67 VGND VGND VPWR VPWR sky130_fd_sc_hd__fill_1
XFILLER_41_234 VGND VGND VPWR VPWR sky130_fd_sc_hd__fill_1
XFILLER_41_201 VGND VGND VPWR VPWR sky130_fd_sc_hd__decap_6
XFILLER_32_256 VGND VGND VPWR VPWR sky130_fd_sc_hd__fill_2
XFILLER_32_212 VGND VGND VPWR VPWR sky130_fd_sc_hd__fill_2
XFILLER_17_220 VGND VGND VPWR VPWR sky130_fd_sc_hd__decap_4
XFILLER_17_275 VGND VGND VPWR VPWR sky130_fd_sc_hd__fill_1
XFILLER_4_83 VGND VGND VPWR VPWR sky130_fd_sc_hd__fill_1
X_1514_ _0164_ _0612_ _0613_ _0609_ VGND VGND VPWR VPWR _0635_ sky130_fd_sc_hd__a2bb2o_4
X_1445_ net225 net118 _0565_ net159 _0568_ VGND VGND VPWR VPWR _0569_ sky130_fd_sc_hd__o221a_1
XTAP_TAPCELL_ROW_10_170 VGND VPWR sky130_fd_sc_hd__tapvpwrvgnd_1
XTAP_TAPCELL_ROW_2_127 VGND VPWR sky130_fd_sc_hd__tapvpwrvgnd_1
X_1376_ net228 _0500_ net151 VGND VGND VPWR VPWR _0502_ sky130_fd_sc_hd__o21a_1
XTAP_TAPCELL_ROW_33_295 VGND VPWR sky130_fd_sc_hd__tapvpwrvgnd_1
XFILLER_23_15 VPWR VGND VPWR VGND sky130_ef_sc_hd__decap_12
XFILLER_48_12 VPWR VGND VPWR VGND sky130_ef_sc_hd__decap_12
XFILLER_14_201 VGND VGND VPWR VPWR sky130_fd_sc_hd__fill_1
XFILLER_9_39 VGND VGND VPWR VPWR sky130_fd_sc_hd__decap_4
XFILLER_14_289 VPWR VGND VPWR VGND sky130_ef_sc_hd__decap_12
XFILLER_36_7 VPWR VGND VPWR VGND sky130_ef_sc_hd__decap_12
XFILLER_52_307 VGND VGND VPWR VPWR sky130_fd_sc_hd__fill_1
X_1092_ net182 net117 VGND VGND VPWR VPWR _0225_ sky130_fd_sc_hd__nor2_1
X_1230_ net193 net161 VGND VGND VPWR VPWR _0360_ sky130_fd_sc_hd__nor2_1
X_1161_ net202 _0287_ _0291_ _0285_ VGND VGND VPWR VPWR _0293_ sky130_fd_sc_hd__a31o_1
XTAP_TAPCELL_ROW_47_376 VGND VPWR sky130_fd_sc_hd__tapvpwrvgnd_1
X_1994_ net114 _0083_ _0078_ VGND VGND VPWR VPWR _0084_ sky130_fd_sc_hd__a21oi_1
XFILLER_18_15 VPWR VGND VPWR VGND sky130_ef_sc_hd__decap_12
X_1428_ _0183_ _0552_ VGND VGND VPWR VPWR _0553_ sky130_fd_sc_hd__nand2_2
X_1359_ _0345_ _0482_ _0485_ _0189_ _0226_ VGND VGND VPWR VPWR _0486_ sky130_fd_sc_hd__o221a_1
XPHY_EDGE_ROW_41_Left_95 VGND VGND VPWR VPWR sky130_fd_sc_hd__decap_3
XTAP_TAPCELL_ROW_21_232 VGND VPWR sky130_fd_sc_hd__tapvpwrvgnd_1
Xfanout250 net12 VGND VGND VPWR VPWR net250 sky130_fd_sc_hd__buf_2
XFILLER_19_304 VGND VGND VPWR VPWR sky130_fd_sc_hd__fill_1
XTAP_TAPCELL_ROW_44_357 VGND VPWR sky130_fd_sc_hd__tapvpwrvgnd_1
XFILLER_34_318 VGND VGND VPWR VPWR sky130_fd_sc_hd__decap_4
XFILLER_6_296 VPWR VGND VPWR VGND sky130_ef_sc_hd__decap_12
XFILLER_10_292 VGND VGND VPWR VPWR sky130_fd_sc_hd__decap_3
X_1213_ net193 net146 VGND VGND VPWR VPWR _0344_ sky130_fd_sc_hd__nor2_2
XFILLER_27_3 VPWR VGND VPWR VGND sky130_ef_sc_hd__decap_12
XFILLER_52_148 VGND VGND VPWR VPWR sky130_fd_sc_hd__decap_4
X_1144_ net250 net211 _0275_ VGND VGND VPWR VPWR _0276_ sky130_fd_sc_hd__a21o_1
XFILLER_1_51 VGND VGND VPWR VPWR sky130_fd_sc_hd__decap_4
X_1075_ _0194_ _0195_ VGND VGND VPWR VPWR _0208_ sky130_fd_sc_hd__and2b_1
X_1977_ net237 _0064_ net157 VGND VGND VPWR VPWR _0065_ sky130_fd_sc_hd__o21ai_1
XFILLER_20_27 VGND VGND VPWR VPWR sky130_fd_sc_hd__fill_1
XFILLER_45_57 VGND VGND VPWR VPWR sky130_fd_sc_hd__decap_4
XFILLER_43_159 VGND VGND VPWR VPWR sky130_fd_sc_hd__decap_8
XFILLER_43_137 VPWR VGND VPWR VGND sky130_ef_sc_hd__decap_12
XFILLER_16_318 VGND VGND VPWR VPWR sky130_fd_sc_hd__decap_4
XFILLER_6_29 VPWR VGND VPWR VGND sky130_ef_sc_hd__decap_12
XFILLER_3_211 VPWR VGND VPWR VGND sky130_ef_sc_hd__decap_12
XFILLER_42_192 VGND VGND VPWR VPWR sky130_fd_sc_hd__decap_4
XFILLER_42_181 VGND VGND VPWR VPWR sky130_fd_sc_hd__fill_2
X_1831_ net283 _0939_ VGND VGND VPWR VPWR _0940_ sky130_fd_sc_hd__xnor2_2
X_1900_ _0991_ net124 _0999_ net68 _1006_ VGND VGND VPWR VPWR _1007_ sky130_fd_sc_hd__a221o_1
X_1762_ net197 _0873_ VGND VGND VPWR VPWR _0874_ sky130_fd_sc_hd__or2_1
X_1693_ net252 net42 VGND VGND VPWR VPWR _0808_ sky130_fd_sc_hd__nand2_1
X_1058_ _0181_ net117 VGND VGND VPWR VPWR _0191_ sky130_fd_sc_hd__nor2_1
XFILLER_15_27 VPWR VGND VPWR VGND sky130_ef_sc_hd__decap_12
X_1127_ net146 net115 VGND VGND VPWR VPWR _0260_ sky130_fd_sc_hd__and2_2
XFILLER_31_15 VPWR VGND VPWR VGND sky130_ef_sc_hd__decap_12
XPHY_EDGE_ROW_1_Right_1 VGND VGND VPWR VPWR sky130_fd_sc_hd__decap_3
XFILLER_0_225 VGND VGND VPWR VPWR sky130_fd_sc_hd__decap_3
XFILLER_48_229 VGND VGND VPWR VPWR sky130_fd_sc_hd__decap_4
XFILLER_31_129 VGND VGND VPWR VPWR sky130_fd_sc_hd__fill_1
XFILLER_31_107 VGND VGND VPWR VPWR sky130_fd_sc_hd__decap_4
XFILLER_21_70 VGND VGND VPWR VPWR sky130_fd_sc_hd__decap_3
X_2030_ _0741_ net79 _0714_ VGND VGND VPWR VPWR _0122_ sky130_fd_sc_hd__mux2_1
XFILLER_22_118 VGND VGND VPWR VPWR sky130_fd_sc_hd__fill_1
X_1745_ _0358_ _0656_ _0857_ _0344_ net191 VGND VGND VPWR VPWR _0858_ sky130_fd_sc_hd__a221o_1
XFILLER_30_162 VGND VGND VPWR VPWR sky130_fd_sc_hd__fill_1
X_1814_ net246 net48 VGND VGND VPWR VPWR _0924_ sky130_fd_sc_hd__nor2_1
X_1676_ _0791_ VGND VGND VPWR VPWR net81 sky130_fd_sc_hd__inv_2
XFILLER_38_284 VGND VGND VPWR VPWR sky130_fd_sc_hd__decap_6
XFILLER_38_251 VGND VGND VPWR VPWR sky130_fd_sc_hd__fill_1
XFILLER_26_37 VGND VGND VPWR VPWR sky130_fd_sc_hd__decap_8
XFILLER_26_15 VPWR VGND VPWR VGND sky130_ef_sc_hd__decap_12
X_1392_ net181 _0517_ _0248_ VGND VGND VPWR VPWR _0518_ sky130_fd_sc_hd__o21ai_1
X_1461_ net242 _0583_ net152 VGND VGND VPWR VPWR _0584_ sky130_fd_sc_hd__o21a_1
X_1530_ _0647_ _0649_ _0650_ net126 VGND VGND VPWR VPWR _0651_ sky130_fd_sc_hd__a31o_1
X_2013_ net235 net57 net132 VGND VGND VPWR VPWR _0104_ sky130_fd_sc_hd__a21oi_1
XFILLER_50_213 VPWR VGND VPWR VGND sky130_ef_sc_hd__decap_12
XFILLER_2_309 VPWR VGND VPWR VGND sky130_ef_sc_hd__decap_12
X_1728_ net155 _0840_ VGND VGND VPWR VPWR _0841_ sky130_fd_sc_hd__nand2_1
X_1659_ net41 net137 net130 _0170_ VGND VGND VPWR VPWR _0775_ sky130_fd_sc_hd__o2bb2a_1
XFILLER_26_232 VGND VGND VPWR VPWR sky130_fd_sc_hd__decap_8
XFILLER_26_210 VGND VGND VPWR VPWR sky130_fd_sc_hd__fill_1
XFILLER_53_57 VGND VGND VPWR VPWR sky130_fd_sc_hd__fill_1
XTAP_TAPCELL_ROW_10_171 VGND VPWR sky130_fd_sc_hd__tapvpwrvgnd_1
X_1375_ net151 _0500_ VGND VGND VPWR VPWR _0501_ sky130_fd_sc_hd__nand2_1
X_1444_ net225 net64 net109 _0564_ _0567_ VGND VGND VPWR VPWR _0568_ sky130_fd_sc_hd__o311a_1
X_1513_ _0634_ net169 VGND VGND VPWR VPWR net75 sky130_fd_sc_hd__nor2_4
XTAP_TAPCELL_ROW_2_128 VGND VPWR sky130_fd_sc_hd__tapvpwrvgnd_1
XTAP_TAPCELL_ROW_33_296 VGND VPWR sky130_fd_sc_hd__tapvpwrvgnd_1
XFILLER_23_27 VPWR VGND VPWR VGND sky130_ef_sc_hd__decap_12
XFILLER_48_24 VGND VGND VPWR VPWR sky130_fd_sc_hd__decap_4
XFILLER_46_305 VGND VGND VPWR VPWR sky130_fd_sc_hd__decap_3
XFILLER_1_150 VGND VGND VPWR VPWR sky130_fd_sc_hd__fill_1
XFILLER_49_165 VGND VGND VPWR VPWR sky130_fd_sc_hd__decap_3
XFILLER_49_143 VGND VGND VPWR VPWR sky130_fd_sc_hd__decap_3
X_1091_ _0216_ _0223_ net195 VGND VGND VPWR VPWR _0224_ sky130_fd_sc_hd__mux2_1
X_1160_ net256 _0285_ _0291_ VGND VGND VPWR VPWR _0292_ sky130_fd_sc_hd__nor3_1
X_1993_ net172 _0896_ _1001_ _0241_ _0082_ VGND VGND VPWR VPWR _0083_ sky130_fd_sc_hd__o221a_1
XFILLER_20_227 VPWR VGND VPWR VGND sky130_ef_sc_hd__decap_12
X_1358_ net196 _0484_ _0483_ VGND VGND VPWR VPWR _0485_ sky130_fd_sc_hd__a21oi_1
XFILLER_18_27 VGND VGND VPWR VPWR sky130_fd_sc_hd__fill_1
X_1427_ net254 _0542_ _0551_ net257 _0536_ VGND VGND VPWR VPWR _0552_ sky130_fd_sc_hd__a221o_1
X_1289_ _0229_ _0213_ net205 VGND VGND VPWR VPWR _0418_ sky130_fd_sc_hd__mux2_1
XTAP_TAPCELL_ROW_38_322 VGND VPWR sky130_fd_sc_hd__tapvpwrvgnd_1
XFILLER_34_15 VPWR VGND VPWR VGND sky130_ef_sc_hd__decap_12
XFILLER_11_216 VGND VGND VPWR VPWR sky130_fd_sc_hd__decap_8
XTAP_TAPCELL_ROW_21_233 VGND VPWR sky130_fd_sc_hd__tapvpwrvgnd_1
Xfanout240 net21 VGND VGND VPWR VPWR net240 sky130_fd_sc_hd__clkbuf_2
Xfanout251 net11 VGND VGND VPWR VPWR net251 sky130_fd_sc_hd__clkbuf_4
XFILLER_46_146 VPWR VGND VPWR VGND sky130_ef_sc_hd__decap_12
XTAP_TAPCELL_ROW_44_358 VGND VPWR sky130_fd_sc_hd__tapvpwrvgnd_1
XFILLER_6_253 VGND VGND VPWR VPWR sky130_fd_sc_hd__decap_6
XFILLER_37_113 VGND VGND VPWR VPWR sky130_fd_sc_hd__decap_6
X_1212_ net199 _0342_ VGND VGND VPWR VPWR _0343_ sky130_fd_sc_hd__nor2_1
X_1143_ net141 _0273_ net128 VGND VGND VPWR VPWR _0275_ sky130_fd_sc_hd__o21a_1
X_1074_ _0184_ net66 net188 VGND VGND VPWR VPWR _0207_ sky130_fd_sc_hd__or3b_4
X_1976_ net56 net164 net141 _0063_ VGND VGND VPWR VPWR _0064_ sky130_fd_sc_hd__o211ai_1
XFILLER_29_15 VPWR VGND VPWR VGND sky130_ef_sc_hd__decap_12
XFILLER_43_105 VGND VGND VPWR VPWR sky130_fd_sc_hd__decap_6
XFILLER_43_149 VGND VGND VPWR VPWR sky130_fd_sc_hd__decap_4
XTAP_TAPCELL_ROW_41_339 VGND VPWR sky130_fd_sc_hd__tapvpwrvgnd_1
XFILLER_6_19 VGND VGND VPWR VPWR sky130_fd_sc_hd__decap_8
XFILLER_3_223 VGND VGND VPWR VPWR sky130_fd_sc_hd__fill_1
XFILLER_10_61 VGND VGND VPWR VPWR sky130_fd_sc_hd__fill_2
XFILLER_10_72 VPWR VGND VPWR VGND sky130_ef_sc_hd__decap_12
X_1761_ _0872_ _0778_ net203 VGND VGND VPWR VPWR _0873_ sky130_fd_sc_hd__mux2_1
X_1830_ _0936_ _0938_ VGND VGND VPWR VPWR _0939_ sky130_fd_sc_hd__and2_1
X_1692_ net252 net42 VGND VGND VPWR VPWR _0807_ sky130_fd_sc_hd__nor2_1
X_1126_ net1 net216 net109 VGND VGND VPWR VPWR _0259_ sky130_fd_sc_hd__or3_1
XFILLER_33_160 VGND VGND VPWR VPWR sky130_fd_sc_hd__fill_1
X_1057_ net166 net158 VGND VGND VPWR VPWR _0190_ sky130_fd_sc_hd__or2_2
XFILLER_25_149 VGND VGND VPWR VPWR sky130_fd_sc_hd__decap_4
XFILLER_25_116 VGND VGND VPWR VPWR sky130_fd_sc_hd__decap_6
XFILLER_15_39 VGND VGND VPWR VPWR sky130_fd_sc_hd__decap_4
XFILLER_18_190 VGND VGND VPWR VPWR sky130_fd_sc_hd__decap_6
X_1959_ _0046_ _0045_ _0410_ VGND VGND VPWR VPWR _0047_ sky130_fd_sc_hd__o21ai_1
XFILLER_31_27 VPWR VGND VPWR VGND sky130_ef_sc_hd__decap_12
XFILLER_47_252 VPWR VGND VPWR VGND sky130_ef_sc_hd__decap_12
XFILLER_47_241 VGND VGND VPWR VPWR sky130_fd_sc_hd__decap_6
XFILLER_39_208 VGND VGND VPWR VPWR sky130_fd_sc_hd__decap_6
XFILLER_15_160 VGND VGND VPWR VPWR sky130_fd_sc_hd__fill_1
X_1744_ _0856_ _0760_ net205 VGND VGND VPWR VPWR _0857_ sky130_fd_sc_hd__mux2_1
XFILLER_30_141 VGND VGND VPWR VPWR sky130_fd_sc_hd__decap_6
X_1813_ net246 net48 VGND VGND VPWR VPWR _0923_ sky130_fd_sc_hd__and2_1
X_1675_ net170 _0790_ VGND VGND VPWR VPWR _0791_ sky130_fd_sc_hd__or2_4
XPHY_EDGE_ROW_15_Right_15 VGND VGND VPWR VPWR sky130_fd_sc_hd__decap_3
X_1109_ net232 net231 net218 VGND VGND VPWR VPWR _0242_ sky130_fd_sc_hd__mux2_1
XFILLER_26_27 VGND VGND VPWR VPWR sky130_fd_sc_hd__fill_1
XPHY_EDGE_ROW_24_Right_24 VGND VGND VPWR VPWR sky130_fd_sc_hd__decap_3
XFILLER_53_277 VGND VGND VPWR VPWR sky130_fd_sc_hd__decap_3
XFILLER_13_119 VGND VGND VPWR VPWR sky130_fd_sc_hd__decap_6
XPHY_EDGE_ROW_33_Right_33 VGND VGND VPWR VPWR sky130_fd_sc_hd__decap_3
XFILLER_44_233 VGND VGND VPWR VPWR sky130_fd_sc_hd__fill_1
XPHY_EDGE_ROW_42_Right_42 VGND VGND VPWR VPWR sky130_fd_sc_hd__decap_3
XFILLER_29_285 VGND VGND VPWR VPWR sky130_fd_sc_hd__fill_1
XPHY_EDGE_ROW_51_Right_51 VGND VGND VPWR VPWR sky130_fd_sc_hd__decap_3
XFILLER_8_101 VGND VGND VPWR VPWR sky130_fd_sc_hd__decap_4
XFILLER_8_123 VGND VGND VPWR VPWR sky130_fd_sc_hd__fill_1
XFILLER_12_141 VGND VGND VPWR VPWR sky130_fd_sc_hd__decap_3
X_1391_ _0377_ _0516_ _0514_ net194 VGND VGND VPWR VPWR _0517_ sky130_fd_sc_hd__o2bb2a_1
X_1460_ net34 net147 net142 _0582_ VGND VGND VPWR VPWR _0583_ sky130_fd_sc_hd__a211o_1
X_2012_ net165 net110 _0102_ VGND VGND VPWR VPWR _0103_ sky130_fd_sc_hd__mux2_1
XFILLER_50_225 VPWR VGND VPWR VGND sky130_ef_sc_hd__decap_12
XFILLER_50_203 VGND VGND VPWR VPWR sky130_fd_sc_hd__fill_1
XFILLER_35_299 VGND VGND VPWR VPWR sky130_fd_sc_hd__decap_4
X_1727_ net45 net162 net140 _0839_ VGND VGND VPWR VPWR _0840_ sky130_fd_sc_hd__o211ai_1
XFILLER_12_29 VGND VGND VPWR VPWR sky130_fd_sc_hd__decap_4
X_1658_ net280 _0773_ VGND VGND VPWR VPWR _0774_ sky130_fd_sc_hd__xnor2_1
XFILLER_37_15 VPWR VGND VPWR VGND sky130_ef_sc_hd__decap_12
X_1589_ net115 _0690_ _0706_ _0707_ VGND VGND VPWR VPWR _0708_ sky130_fd_sc_hd__a22o_1
XFILLER_53_47 VGND VGND VPWR VPWR sky130_fd_sc_hd__fill_1
XFILLER_49_303 VGND VGND VPWR VPWR sky130_fd_sc_hd__decap_8
XFILLER_1_321 VGND VGND VPWR VPWR sky130_fd_sc_hd__fill_1
XFILLER_32_225 VGND VGND VPWR VPWR sky130_fd_sc_hd__fill_1
XTAP_TAPCELL_ROW_10_172 VGND VPWR sky130_fd_sc_hd__tapvpwrvgnd_1
X_1512_ _0058_ _0623_ _0633_ _0249_ _0617_ VGND VGND VPWR VPWR _0634_ sky130_fd_sc_hd__o221a_4
XFILLER_4_41 VPWR VGND VPWR VGND sky130_ef_sc_hd__decap_12
X_1443_ net225 net64 _0566_ VGND VGND VPWR VPWR _0567_ sky130_fd_sc_hd__a21o_1
X_1374_ net62 net159 net139 _0499_ VGND VGND VPWR VPWR _0500_ sky130_fd_sc_hd__o211ai_1
XTAP_TAPCELL_ROW_2_129 VGND VPWR sky130_fd_sc_hd__tapvpwrvgnd_1
XFILLER_23_225 VGND VGND VPWR VPWR sky130_fd_sc_hd__decap_4
XTAP_TAPCELL_ROW_33_297 VGND VPWR sky130_fd_sc_hd__tapvpwrvgnd_1
XFILLER_23_39 VGND VGND VPWR VPWR sky130_fd_sc_hd__fill_2
XFILLER_14_247 VGND VGND VPWR VPWR sky130_fd_sc_hd__decap_4
XFILLER_13_94 VGND VGND VPWR VPWR sky130_fd_sc_hd__decap_4
XFILLER_49_111 VGND VGND VPWR VPWR sky130_fd_sc_hd__fill_1
XFILLER_52_309 VPWR VGND VPWR VGND sky130_ef_sc_hd__decap_12
X_1090_ _0222_ VGND VGND VPWR VPWR _0223_ sky130_fd_sc_hd__inv_2
X_1992_ net212 _0032_ _0081_ _0238_ VGND VGND VPWR VPWR _0082_ sky130_fd_sc_hd__a211o_1
XTAP_TAPCELL_ROW_30_278 VGND VPWR sky130_fd_sc_hd__tapvpwrvgnd_1
XFILLER_13_291 VGND VGND VPWR VPWR sky130_fd_sc_hd__decap_6
X_1357_ _0334_ _0322_ net205 VGND VGND VPWR VPWR _0484_ sky130_fd_sc_hd__mux2_1
X_1426_ _0225_ _0549_ _0550_ VGND VGND VPWR VPWR _0551_ sky130_fd_sc_hd__a21o_1
XTAP_TAPCELL_ROW_38_323 VGND VPWR sky130_fd_sc_hd__tapvpwrvgnd_1
X_1288_ net190 _0416_ VGND VGND VPWR VPWR _0417_ sky130_fd_sc_hd__nand2_1
XFILLER_43_309 VGND VGND VPWR VPWR sky130_fd_sc_hd__fill_1
XFILLER_34_27 VGND VGND VPWR VPWR sky130_fd_sc_hd__fill_1
XFILLER_11_228 VPWR VGND VPWR VGND sky130_ef_sc_hd__decap_12
XFILLER_50_15 VPWR VGND VPWR VGND sky130_ef_sc_hd__decap_12
Xfanout241 net20 VGND VGND VPWR VPWR net241 sky130_fd_sc_hd__buf_2
Xfanout252 net10 VGND VGND VPWR VPWR net252 sky130_fd_sc_hd__buf_2
Xfanout230 net29 VGND VGND VPWR VPWR net230 sky130_fd_sc_hd__buf_2
XFILLER_46_158 VPWR VGND VPWR VGND sky130_ef_sc_hd__decap_12
XTAP_TAPCELL_ROW_44_359 VGND VPWR sky130_fd_sc_hd__tapvpwrvgnd_1
X_1211_ _0089_ net216 net180 _0341_ VGND VGND VPWR VPWR _0342_ sky130_fd_sc_hd__o31a_1
X_1142_ net250 net211 net109 VGND VGND VPWR VPWR _0274_ sky130_fd_sc_hd__or3_1
X_1073_ _0184_ _0178_ net272 VGND VGND VPWR VPWR _0206_ sky130_fd_sc_hd__and3b_1
X_1975_ net56 net150 VGND VGND VPWR VPWR _0063_ sky130_fd_sc_hd__nand2_1
XFILLER_20_29 VPWR VGND VPWR VGND sky130_ef_sc_hd__decap_12
XFILLER_29_27 VGND VGND VPWR VPWR sky130_fd_sc_hd__decap_4
X_1409_ _0528_ _0533_ VGND VGND VPWR VPWR _0534_ sky130_fd_sc_hd__xor2_1
XFILLER_45_15 VPWR VGND VPWR VGND sky130_ef_sc_hd__decap_12
XFILLER_51_161 VGND VGND VPWR VPWR sky130_fd_sc_hd__decap_6
XFILLER_3_235 VGND VGND VPWR VPWR sky130_fd_sc_hd__fill_2
XFILLER_3_202 VGND VGND VPWR VPWR sky130_fd_sc_hd__fill_2
X_1760_ _0824_ _0871_ net178 VGND VGND VPWR VPWR _0872_ sky130_fd_sc_hd__mux2_1
X_1691_ net191 _0346_ net107 _0805_ VGND VGND VPWR VPWR _0806_ sky130_fd_sc_hd__a211o_1
XFILLER_32_3 VPWR VGND VPWR VGND sky130_ef_sc_hd__decap_12
X_1125_ net134 net115 VGND VGND VPWR VPWR _0258_ sky130_fd_sc_hd__and2_1
X_1056_ net158 net166 VGND VGND VPWR VPWR _0189_ sky130_fd_sc_hd__nor2_8
XFILLER_31_39 VGND VGND VPWR VPWR sky130_fd_sc_hd__decap_6
X_1958_ net54 net138 net133 net239 VGND VGND VPWR VPWR _0046_ sky130_fd_sc_hd__a22o_1
X_1889_ net140 _0992_ net130 VGND VGND VPWR VPWR _0996_ sky130_fd_sc_hd__o21a_1
XFILLER_48_209 VGND VGND VPWR VPWR sky130_fd_sc_hd__decap_8
XFILLER_16_128 VGND VGND VPWR VPWR sky130_fd_sc_hd__decap_6
XFILLER_24_194 VGND VGND VPWR VPWR sky130_fd_sc_hd__fill_2
XFILLER_47_264 VPWR VGND VPWR VGND sky130_ef_sc_hd__decap_12
XFILLER_22_109 VGND VGND VPWR VPWR sky130_fd_sc_hd__fill_2
X_1743_ _0801_ _0855_ net178 VGND VGND VPWR VPWR _0856_ sky130_fd_sc_hd__mux2_1
X_1812_ _0296_ _0920_ _0921_ _0916_ net257 VGND VGND VPWR VPWR _0922_ sky130_fd_sc_hd__o311a_1
XFILLER_7_63 VPWR VGND VPWR VGND sky130_ef_sc_hd__decap_12
XPHY_EDGE_ROW_15_Left_69 VGND VGND VPWR VPWR sky130_fd_sc_hd__decap_3
X_1674_ _0068_ _0786_ _0789_ _0776_ VGND VGND VPWR VPWR _0790_ sky130_fd_sc_hd__o211a_1
X_1108_ net204 net176 VGND VGND VPWR VPWR _0241_ sky130_fd_sc_hd__nand2_4
X_1039_ net249 VGND VGND VPWR VPWR _0172_ sky130_fd_sc_hd__inv_2
XFILLER_5_308 VPWR VGND VPWR VGND sky130_ef_sc_hd__decap_12
XTAP_TAPCELL_ROW_8_157 VGND VPWR sky130_fd_sc_hd__tapvpwrvgnd_1
XFILLER_12_197 VGND VGND VPWR VPWR sky130_fd_sc_hd__decap_4
X_1390_ net202 net165 _0373_ _0515_ VGND VGND VPWR VPWR _0516_ sky130_fd_sc_hd__o31a_1
XFILLER_35_223 VGND VGND VPWR VPWR sky130_fd_sc_hd__fill_1
XFILLER_35_212 VGND VGND VPWR VPWR sky130_fd_sc_hd__decap_4
X_2011_ net235 net57 VGND VGND VPWR VPWR _0102_ sky130_fd_sc_hd__nor2_1
XFILLER_50_237 VGND VGND VPWR VPWR sky130_fd_sc_hd__decap_4
X_1726_ net45 net149 VGND VGND VPWR VPWR _0839_ sky130_fd_sc_hd__nand2_1
X_1588_ net189 net38 VGND VGND VPWR VPWR _0707_ sky130_fd_sc_hd__nand2_1
X_1657_ _0770_ _0772_ VGND VGND VPWR VPWR _0773_ sky130_fd_sc_hd__and2_1
XFILLER_37_27 VPWR VGND VPWR VGND sky130_ef_sc_hd__decap_12
XFILLER_5_116 VGND VGND VPWR VPWR sky130_fd_sc_hd__decap_6
XFILLER_32_204 VGND VGND VPWR VPWR sky130_fd_sc_hd__decap_8
XFILLER_17_245 VPWR VGND VPWR VGND sky130_ef_sc_hd__decap_12
XTAP_TAPCELL_ROW_19_218 VGND VPWR sky130_fd_sc_hd__tapvpwrvgnd_1
XFILLER_43_92 VGND VGND VPWR VPWR sky130_fd_sc_hd__decap_4
XFILLER_43_81 VGND VGND VPWR VPWR sky130_fd_sc_hd__fill_2
XFILLER_32_237 VGND VGND VPWR VPWR sky130_fd_sc_hd__fill_2
XTAP_TAPCELL_ROW_27_262 VGND VPWR sky130_fd_sc_hd__tapvpwrvgnd_1
X_1511_ net192 _0626_ _0632_ VGND VGND VPWR VPWR _0633_ sky130_fd_sc_hd__a21oi_1
X_1442_ net139 _0565_ net127 VGND VGND VPWR VPWR _0566_ sky130_fd_sc_hd__o21a_1
XTAP_TAPCELL_ROW_10_173 VGND VPWR sky130_fd_sc_hd__tapvpwrvgnd_1
XFILLER_4_53 VPWR VGND VPWR VGND sky130_ef_sc_hd__decap_12
X_1373_ net62 net147 VGND VGND VPWR VPWR _0499_ sky130_fd_sc_hd__nand2_1
XTAP_TAPCELL_ROW_33_298 VGND VPWR sky130_fd_sc_hd__tapvpwrvgnd_1
X_1709_ net175 _0390_ net112 _0548_ VGND VGND VPWR VPWR _0823_ sky130_fd_sc_hd__a31o_1
XPHY_EDGE_ROW_18_Left_72 VGND VGND VPWR VPWR sky130_fd_sc_hd__decap_3
XFILLER_14_226 VGND VGND VPWR VPWR sky130_fd_sc_hd__decap_6
XFILLER_1_163 VGND VGND VPWR VPWR sky130_fd_sc_hd__fill_2
XFILLER_1_196 VGND VGND VPWR VPWR sky130_fd_sc_hd__decap_6
X_1991_ net214 _0080_ VGND VGND VPWR VPWR _0081_ sky130_fd_sc_hd__nor2_1
XTAP_TAPCELL_ROW_30_279 VGND VPWR sky130_fd_sc_hd__tapvpwrvgnd_1
XFILLER_20_218 VGND VGND VPWR VPWR sky130_fd_sc_hd__fill_1
X_1425_ net113 _0545_ _0546_ net111 VGND VGND VPWR VPWR _0550_ sky130_fd_sc_hd__a22o_1
X_1356_ _0240_ _0333_ _0336_ _0237_ VGND VGND VPWR VPWR _0483_ sky130_fd_sc_hd__a22o_1
XTAP_TAPCELL_ROW_38_324 VGND VPWR sky130_fd_sc_hd__tapvpwrvgnd_1
X_1287_ net196 _0370_ _0415_ _0414_ net255 VGND VGND VPWR VPWR _0416_ sky130_fd_sc_hd__a311o_1
XFILLER_18_29 VGND VGND VPWR VPWR sky130_fd_sc_hd__decap_6
XFILLER_50_27 VGND VGND VPWR VPWR sky130_fd_sc_hd__fill_1
Xfanout242 net2 VGND VGND VPWR VPWR net242 sky130_fd_sc_hd__buf_2
Xfanout231 net28 VGND VGND VPWR VPWR net231 sky130_fd_sc_hd__buf_2
Xfanout220 net224 VGND VGND VPWR VPWR net220 sky130_fd_sc_hd__buf_8
XPHY_EDGE_ROW_3_Left_57 VGND VGND VPWR VPWR sky130_fd_sc_hd__decap_3
XFILLER_10_284 VGND VGND VPWR VPWR sky130_fd_sc_hd__decap_8
XFILLER_24_72 VGND VGND VPWR VPWR sky130_fd_sc_hd__decap_6
XFILLER_24_94 VGND VGND VPWR VPWR sky130_fd_sc_hd__fill_2
XFILLER_6_277 VGND VGND VPWR VPWR sky130_fd_sc_hd__fill_1
XFILLER_37_126 VGND VGND VPWR VPWR sky130_fd_sc_hd__fill_1
X_1210_ net180 _0340_ VGND VGND VPWR VPWR _0341_ sky130_fd_sc_hd__nand2_1
X_1072_ _0191_ _0204_ VGND VGND VPWR VPWR _0205_ sky130_fd_sc_hd__xnor2_1
X_1141_ net250 net211 VGND VGND VPWR VPWR _0273_ sky130_fd_sc_hd__nor2_1
X_1974_ _0041_ _0038_ _0042_ VGND VGND VPWR VPWR _0062_ sky130_fd_sc_hd__a21o_1
XPHY_EDGE_ROW_45_Left_99 VGND VGND VPWR VPWR sky130_fd_sc_hd__decap_3
X_1408_ _0161_ _0531_ _0532_ VGND VGND VPWR VPWR _0533_ sky130_fd_sc_hd__o21ai_1
XFILLER_45_27 VPWR VGND VPWR VGND sky130_ef_sc_hd__decap_12
XFILLER_36_181 VGND VGND VPWR VPWR sky130_fd_sc_hd__decap_4
X_1339_ _0153_ _0436_ _0437_ _0433_ VGND VGND VPWR VPWR _0466_ sky130_fd_sc_hd__a2bb2o_4
XFILLER_10_41 VPWR VGND VPWR VGND sky130_ef_sc_hd__decap_12
XFILLER_10_85 VGND VGND VPWR VPWR sky130_fd_sc_hd__decap_8
XFILLER_19_137 VGND VGND VPWR VPWR sky130_fd_sc_hd__decap_8
X_1690_ net181 _0332_ _0804_ net113 VGND VGND VPWR VPWR _0805_ sky130_fd_sc_hd__a22o_1
XFILLER_25_3 VPWR VGND VPWR VGND sky130_ef_sc_hd__decap_12
X_1124_ net65 _0178_ net170 net272 VGND VGND VPWR VPWR _0257_ sky130_fd_sc_hd__or4b_4
X_1055_ net65 _0178_ net272 net170 VGND VGND VPWR VPWR _0188_ sky130_fd_sc_hd__or4_1
X_1957_ _0038_ _0044_ VGND VGND VPWR VPWR _0045_ sky130_fd_sc_hd__xnor2_1
XFILLER_33_140 VGND VGND VPWR VPWR sky130_fd_sc_hd__decap_4
XFILLER_0_217 VGND VGND VPWR VPWR sky130_fd_sc_hd__fill_1
X_1888_ net243 net119 VGND VGND VPWR VPWR _0995_ sky130_fd_sc_hd__nor2_1
XFILLER_24_173 VGND VGND VPWR VPWR sky130_fd_sc_hd__fill_1
XFILLER_8_306 VGND VGND VPWR VPWR sky130_fd_sc_hd__fill_2
XFILLER_47_276 VGND VGND VPWR VPWR sky130_fd_sc_hd__decap_4
XPHY_EDGE_ROW_6_Left_60 VGND VGND VPWR VPWR sky130_fd_sc_hd__decap_3
X_1811_ net172 _0735_ VGND VGND VPWR VPWR _0921_ sky130_fd_sc_hd__nor2_1
X_1742_ net249 net11 net223 VGND VGND VPWR VPWR _0855_ sky130_fd_sc_hd__mux2_1
XFILLER_7_75 VPWR VGND VPWR VGND sky130_ef_sc_hd__decap_12
X_1673_ _0783_ _0784_ _0788_ net126 VGND VGND VPWR VPWR _0789_ sky130_fd_sc_hd__a31o_1
XFILLER_53_235 VGND VGND VPWR VPWR sky130_fd_sc_hd__fill_1
X_1107_ net200 net174 VGND VGND VPWR VPWR _0240_ sky130_fd_sc_hd__and2_1
XFILLER_26_29 VGND VGND VPWR VPWR sky130_fd_sc_hd__fill_1
XPHY_EDGE_ROW_5_Right_5 VGND VGND VPWR VPWR sky130_fd_sc_hd__decap_3
X_1038_ net251 VGND VGND VPWR VPWR _0171_ sky130_fd_sc_hd__inv_2
XFILLER_21_110 VGND VGND VPWR VPWR sky130_fd_sc_hd__fill_2
XFILLER_21_176 VGND VGND VPWR VPWR sky130_fd_sc_hd__decap_4
XTAP_TAPCELL_ROW_8_158 VGND VPWR sky130_fd_sc_hd__tapvpwrvgnd_1
XFILLER_44_246 VGND VGND VPWR VPWR sky130_fd_sc_hd__decap_6
XFILLER_44_213 VGND VGND VPWR VPWR sky130_fd_sc_hd__decap_4
XPHY_EDGE_ROW_32_Left_86 VGND VGND VPWR VPWR sky130_fd_sc_hd__decap_3
XFILLER_12_110 VGND VGND VPWR VPWR sky130_fd_sc_hd__decap_6
X_2010_ _0098_ _0099_ _0250_ VGND VGND VPWR VPWR _0101_ sky130_fd_sc_hd__a21oi_1
X_1725_ _0171_ _0817_ _0818_ _0814_ VGND VGND VPWR VPWR _0838_ sky130_fd_sc_hd__a2bb2o_4
X_1587_ net189 net38 VGND VGND VPWR VPWR _0706_ sky130_fd_sc_hd__or2_1
X_1656_ _0771_ VGND VGND VPWR VPWR _0772_ sky130_fd_sc_hd__inv_2
XFILLER_37_39 VPWR VGND VPWR VGND sky130_ef_sc_hd__decap_12
XFILLER_53_27 VGND VGND VPWR VPWR sky130_fd_sc_hd__fill_1
XFILLER_53_16 VGND VGND VPWR VPWR sky130_fd_sc_hd__fill_2
XFILLER_41_216 VGND VGND VPWR VPWR sky130_fd_sc_hd__decap_8
XTAP_TAPCELL_ROW_27_263 VGND VPWR sky130_fd_sc_hd__tapvpwrvgnd_1
XFILLER_17_257 VGND VGND VPWR VPWR sky130_fd_sc_hd__decap_3
XFILLER_17_279 VGND VGND VPWR VPWR sky130_fd_sc_hd__fill_1
XTAP_TAPCELL_ROW_19_219 VGND VPWR sky130_fd_sc_hd__tapvpwrvgnd_1
X_1510_ net111 _0627_ _0631_ net113 VGND VGND VPWR VPWR _0632_ sky130_fd_sc_hd__a22o_1
XFILLER_4_65 VGND VGND VPWR VPWR sky130_fd_sc_hd__decap_3
X_1441_ net225 net64 VGND VGND VPWR VPWR _0565_ sky130_fd_sc_hd__nor2_1
X_1372_ _0159_ _0469_ _0470_ _0466_ VGND VGND VPWR VPWR _0498_ sky130_fd_sc_hd__a2bb2o_4
XFILLER_23_238 VPWR VGND VPWR VGND sky130_ef_sc_hd__decap_12
XTAP_TAPCELL_ROW_33_299 VGND VPWR sky130_fd_sc_hd__tapvpwrvgnd_1
X_1708_ _0821_ _0820_ net123 VGND VGND VPWR VPWR _0822_ sky130_fd_sc_hd__a21o_1
X_1639_ net40 net134 net118 VGND VGND VPWR VPWR _0756_ sky130_fd_sc_hd__o21ai_1
XTAP_TAPCELL_ROW_1_120 VGND VPWR sky130_fd_sc_hd__tapvpwrvgnd_1
XFILLER_22_271 VGND VGND VPWR VPWR sky130_fd_sc_hd__decap_4
XFILLER_22_282 VGND VGND VPWR VPWR sky130_fd_sc_hd__fill_1
XFILLER_22_293 VGND VGND VPWR VPWR sky130_fd_sc_hd__decap_8
XFILLER_49_179 VGND VGND VPWR VPWR sky130_fd_sc_hd__fill_1
X_1990_ net224 net239 _0218_ VGND VGND VPWR VPWR _0080_ sky130_fd_sc_hd__a21oi_1
XTAP_TAPCELL_ROW_15_200 VGND VPWR sky130_fd_sc_hd__tapvpwrvgnd_1
X_1424_ net195 net107 _0547_ VGND VGND VPWR VPWR _0549_ sky130_fd_sc_hd__a21o_1
X_1355_ _0481_ _0342_ net199 VGND VGND VPWR VPWR _0482_ sky130_fd_sc_hd__mux2_1
X_1286_ net204 _0220_ VGND VGND VPWR VPWR _0415_ sky130_fd_sc_hd__nand2b_1
XTAP_TAPCELL_ROW_38_325 VGND VPWR sky130_fd_sc_hd__tapvpwrvgnd_1
XFILLER_34_29 VPWR VGND VPWR VGND sky130_ef_sc_hd__decap_12
Xfanout243 net19 VGND VGND VPWR VPWR net243 sky130_fd_sc_hd__buf_2
Xfanout221 net223 VGND VGND VPWR VPWR net221 sky130_fd_sc_hd__buf_8
Xfanout232 net27 VGND VGND VPWR VPWR net232 sky130_fd_sc_hd__buf_2
XFILLER_46_127 VPWR VGND VPWR VGND sky130_ef_sc_hd__decap_12
Xfanout210 net44 VGND VGND VPWR VPWR net210 sky130_fd_sc_hd__clkbuf_2
XFILLER_42_300 VGND VGND VPWR VPWR sky130_fd_sc_hd__fill_1
XFILLER_6_201 VGND VGND VPWR VPWR sky130_fd_sc_hd__fill_1
XFILLER_49_70 VGND VGND VPWR VPWR sky130_fd_sc_hd__fill_2
XTAP_TAPCELL_ROW_35_306 VGND VPWR sky130_fd_sc_hd__tapvpwrvgnd_1
X_1140_ _0100_ net180 net108 VGND VGND VPWR VPWR _0272_ sky130_fd_sc_hd__or3_1
X_1071_ _0089_ _0202_ _0203_ VGND VGND VPWR VPWR _0204_ sky130_fd_sc_hd__o21bai_1
XFILLER_1_55 VGND VGND VPWR VPWR sky130_fd_sc_hd__fill_1
XFILLER_1_99 VGND VGND VPWR VPWR sky130_fd_sc_hd__fill_1
XTAP_TAPCELL_ROW_43_350 VGND VPWR sky130_fd_sc_hd__tapvpwrvgnd_1
X_1973_ net169 _0061_ VGND VGND VPWR VPWR net94 sky130_fd_sc_hd__nor2_4
XFILLER_28_116 VGND VGND VPWR VPWR sky130_fd_sc_hd__decap_4
X_1407_ net227 _0530_ net151 VGND VGND VPWR VPWR _0532_ sky130_fd_sc_hd__o21a_1
X_1338_ _0465_ VGND VGND VPWR VPWR net100 sky130_fd_sc_hd__inv_2
XFILLER_45_39 VPWR VGND VPWR VGND sky130_ef_sc_hd__decap_12
XFILLER_36_193 VGND VGND VPWR VPWR sky130_fd_sc_hd__decap_3
X_1269_ net161 net134 _0394_ VGND VGND VPWR VPWR _0399_ sky130_fd_sc_hd__mux2_1
XFILLER_10_53 VGND VGND VPWR VPWR sky130_fd_sc_hd__decap_8
XFILLER_35_50 VGND VGND VPWR VPWR sky130_fd_sc_hd__decap_6
XFILLER_2_281 VPWR VGND VPWR VGND sky130_ef_sc_hd__decap_12
X_1123_ net1 net121 _0254_ _0255_ VGND VGND VPWR VPWR _0256_ sky130_fd_sc_hd__o211a_1
X_1054_ net65 net187 _0183_ net66 VGND VGND VPWR VPWR _0187_ sky130_fd_sc_hd__and4bb_1
X_1956_ _0041_ _0043_ VGND VGND VPWR VPWR _0044_ sky130_fd_sc_hd__nand2_1
X_1887_ net116 _0984_ _0992_ _0993_ VGND VGND VPWR VPWR _0994_ sky130_fd_sc_hd__o2bb2a_1
XFILLER_16_108 VGND VGND VPWR VPWR sky130_fd_sc_hd__decap_4
XFILLER_24_141 VGND VGND VPWR VPWR sky130_fd_sc_hd__fill_1
XFILLER_21_85 VGND VGND VPWR VPWR sky130_fd_sc_hd__decap_6
XFILLER_47_222 VGND VGND VPWR VPWR sky130_fd_sc_hd__fill_2
XFILLER_46_82 VGND VGND VPWR VPWR sky130_fd_sc_hd__fill_2
XFILLER_15_152 VGND VGND VPWR VPWR sky130_fd_sc_hd__decap_8
X_1810_ net197 _0919_ VGND VGND VPWR VPWR _0920_ sky130_fd_sc_hd__nor2_1
X_1741_ net125 _0853_ VGND VGND VPWR VPWR _0854_ sky130_fd_sc_hd__nor2_1
XFILLER_7_87 VGND VGND VPWR VPWR sky130_fd_sc_hd__decap_8
X_1672_ net132 _0787_ _0781_ VGND VGND VPWR VPWR _0788_ sky130_fd_sc_hd__o21ai_1
X_1106_ net208 _0236_ net171 _0235_ VGND VGND VPWR VPWR _0239_ sky130_fd_sc_hd__a211o_1
XFILLER_38_277 VGND VGND VPWR VPWR sky130_fd_sc_hd__fill_1
XFILLER_42_29 VPWR VGND VPWR VGND sky130_ef_sc_hd__decap_12
X_1037_ net9 VGND VGND VPWR VPWR _0170_ sky130_fd_sc_hd__inv_2
XFILLER_21_133 VGND VGND VPWR VPWR sky130_fd_sc_hd__decap_6
X_1939_ net145 _0025_ net132 VGND VGND VPWR VPWR _0028_ sky130_fd_sc_hd__a21oi_1
XTAP_TAPCELL_ROW_8_159 VGND VPWR sky130_fd_sc_hd__tapvpwrvgnd_1
XFILLER_8_115 VGND VGND VPWR VPWR sky130_fd_sc_hd__decap_8
XFILLER_8_159 VPWR VGND VPWR VGND sky130_ef_sc_hd__decap_12
XPHY_EDGE_ROW_11_Right_11 VGND VGND VPWR VPWR sky130_fd_sc_hd__decap_3
XFILLER_16_85 VGND VGND VPWR VPWR sky130_fd_sc_hd__fill_2
XFILLER_16_96 VGND VGND VPWR VPWR sky130_fd_sc_hd__decap_3
XPHY_EDGE_ROW_20_Right_20 VGND VGND VPWR VPWR sky130_fd_sc_hd__decap_3
XFILLER_35_225 VPWR VGND VPWR VGND sky130_ef_sc_hd__decap_12
X_1724_ _0837_ net170 VGND VGND VPWR VPWR net83 sky130_fd_sc_hd__nor2_4
XFILLER_7_181 VGND VGND VPWR VPWR sky130_fd_sc_hd__fill_1
X_1586_ net189 net38 VGND VGND VPWR VPWR _0705_ sky130_fd_sc_hd__nor2_1
X_1655_ net9 net156 _0769_ VGND VGND VPWR VPWR _0771_ sky130_fd_sc_hd__and3_1
XTAP_TAPCELL_ROW_4_140 VGND VPWR sky130_fd_sc_hd__tapvpwrvgnd_1
XFILLER_32_217 VGND VGND VPWR VPWR sky130_fd_sc_hd__decap_8
XTAP_TAPCELL_ROW_27_264 VGND VPWR sky130_fd_sc_hd__tapvpwrvgnd_1
XFILLER_27_73 VGND VGND VPWR VPWR sky130_fd_sc_hd__decap_6
XFILLER_17_225 VGND VGND VPWR VPWR sky130_fd_sc_hd__decap_6
XFILLER_17_269 VGND VGND VPWR VPWR sky130_fd_sc_hd__decap_6
XFILLER_4_77 VGND VGND VPWR VPWR sky130_fd_sc_hd__decap_6
X_1440_ _0162_ net108 net64 VGND VGND VPWR VPWR _0564_ sky130_fd_sc_hd__or3b_1
X_1371_ _0497_ VGND VGND VPWR VPWR net101 sky130_fd_sc_hd__inv_2
X_1707_ net43 net137 net129 _0171_ VGND VGND VPWR VPWR _0821_ sky130_fd_sc_hd__o2bb2a_1
X_1638_ net146 _0751_ _0752_ net166 VGND VGND VPWR VPWR _0755_ sky130_fd_sc_hd__a2bb2o_1
X_1569_ net169 _0688_ VGND VGND VPWR VPWR net77 sky130_fd_sc_hd__nor2_2
XTAP_TAPCELL_ROW_1_121 VGND VPWR sky130_fd_sc_hd__tapvpwrvgnd_1
XFILLER_14_217 VGND VGND VPWR VPWR sky130_fd_sc_hd__decap_3
XTAP_TAPCELL_ROW_24_245 VGND VPWR sky130_fd_sc_hd__tapvpwrvgnd_1
XFILLER_1_176 VGND VGND VPWR VPWR sky130_fd_sc_hd__fill_1
XFILLER_49_169 VGND VGND VPWR VPWR sky130_fd_sc_hd__fill_1
XFILLER_38_83 VGND VGND VPWR VPWR sky130_fd_sc_hd__fill_1
X_1285_ net196 _0413_ VGND VGND VPWR VPWR _0414_ sky130_fd_sc_hd__nor2_1
X_1354_ _0480_ VGND VGND VPWR VPWR _0481_ sky130_fd_sc_hd__inv_2
X_1423_ _0079_ _0369_ VGND VGND VPWR VPWR _0548_ sky130_fd_sc_hd__nor2_1
XFILLER_28_309 VGND VGND VPWR VPWR sky130_fd_sc_hd__fill_1
XTAP_TAPCELL_ROW_46_370 VGND VPWR sky130_fd_sc_hd__tapvpwrvgnd_1
XTAP_TAPCELL_ROW_38_326 VGND VPWR sky130_fd_sc_hd__tapvpwrvgnd_1
XFILLER_50_29 VPWR VGND VPWR VGND sky130_ef_sc_hd__decap_12
Xfanout222 net223 VGND VGND VPWR VPWR net222 sky130_fd_sc_hd__clkbuf_2
Xfanout200 net206 VGND VGND VPWR VPWR net200 sky130_fd_sc_hd__clkbuf_4
Xfanout211 net44 VGND VGND VPWR VPWR net211 sky130_fd_sc_hd__buf_2
Xfanout244 net18 VGND VGND VPWR VPWR net244 sky130_fd_sc_hd__buf_2
XFILLER_46_139 VGND VGND VPWR VPWR sky130_fd_sc_hd__fill_1
Xfanout233 net26 VGND VGND VPWR VPWR net233 sky130_fd_sc_hd__buf_2
XFILLER_24_41 VPWR VGND VPWR VGND sky130_ef_sc_hd__decap_12
XFILLER_45_183 VGND VGND VPWR VPWR sky130_fd_sc_hd__decap_3
XTAP_TAPCELL_ROW_35_307 VGND VPWR sky130_fd_sc_hd__tapvpwrvgnd_1
X_1070_ _0089_ _0198_ _0201_ _0193_ VGND VGND VPWR VPWR _0203_ sky130_fd_sc_hd__a31o_1
XTAP_TAPCELL_ROW_43_351 VGND VPWR sky130_fd_sc_hd__tapvpwrvgnd_1
X_1972_ net125 _0053_ _0060_ _0068_ _0047_ VGND VGND VPWR VPWR _0061_ sky130_fd_sc_hd__o221a_4
XPHY_EDGE_ROW_49_Right_49 VGND VGND VPWR VPWR sky130_fd_sc_hd__decap_3
XFILLER_28_139 VGND VGND VPWR VPWR sky130_fd_sc_hd__fill_1
X_1406_ net151 _0530_ VGND VGND VPWR VPWR _0531_ sky130_fd_sc_hd__nand2_1
X_1337_ _0456_ _0441_ _0464_ net170 VGND VGND VPWR VPWR _0465_ sky130_fd_sc_hd__a31o_1
X_1268_ _0395_ _0397_ VGND VGND VPWR VPWR _0398_ sky130_fd_sc_hd__or2_1
X_1199_ net193 _0329_ _0325_ VGND VGND VPWR VPWR _0330_ sky130_fd_sc_hd__a21o_1
XFILLER_42_120 VGND VGND VPWR VPWR sky130_fd_sc_hd__fill_1
XFILLER_42_197 VGND VGND VPWR VPWR sky130_fd_sc_hd__decap_4
X_1122_ net131 _0252_ VGND VGND VPWR VPWR _0255_ sky130_fd_sc_hd__nand2_1
XFILLER_2_293 VPWR VGND VPWR VGND sky130_ef_sc_hd__decap_12
XFILLER_33_175 VGND VGND VPWR VPWR sky130_fd_sc_hd__fill_1
XFILLER_33_164 VGND VGND VPWR VPWR sky130_fd_sc_hd__decap_4
X_1053_ net66 net187 _0184_ VGND VGND VPWR VPWR _0186_ sky130_fd_sc_hd__or3_2
XFILLER_18_172 VPWR VGND VPWR VGND sky130_ef_sc_hd__decap_12
X_1955_ _0042_ VGND VGND VPWR VPWR _0043_ sky130_fd_sc_hd__inv_2
X_1886_ net243 net51 VGND VGND VPWR VPWR _0993_ sky130_fd_sc_hd__and2_1
XFILLER_24_131 VGND VGND VPWR VPWR sky130_fd_sc_hd__decap_4
XFILLER_47_234 VGND VGND VPWR VPWR sky130_fd_sc_hd__decap_4
XFILLER_46_94 VGND VGND VPWR VPWR sky130_fd_sc_hd__decap_8
XFILLER_30_123 VGND VGND VPWR VPWR sky130_fd_sc_hd__fill_1
XFILLER_7_55 VGND VGND VPWR VPWR sky130_fd_sc_hd__fill_1
X_1740_ net249 net119 _0849_ _0850_ _0852_ VGND VGND VPWR VPWR _0853_ sky130_fd_sc_hd__o2111a_1
X_1671_ _0170_ net256 net145 _0782_ VGND VGND VPWR VPWR _0787_ sky130_fd_sc_hd__a22o_1
X_1105_ net200 net195 VGND VGND VPWR VPWR _0238_ sky130_fd_sc_hd__or2_1
XFILLER_38_256 VGND VGND VPWR VPWR sky130_fd_sc_hd__fill_2
XFILLER_38_234 VGND VGND VPWR VPWR sky130_fd_sc_hd__decap_3
XFILLER_38_223 VGND VGND VPWR VPWR sky130_fd_sc_hd__decap_4
XFILLER_38_201 VPWR VGND VPWR VGND sky130_ef_sc_hd__decap_12
X_1036_ net8 VGND VGND VPWR VPWR _0169_ sky130_fd_sc_hd__inv_2
XFILLER_21_167 VGND VGND VPWR VPWR sky130_fd_sc_hd__fill_1
X_1869_ _0241_ _0872_ _0976_ net171 VGND VGND VPWR VPWR _0977_ sky130_fd_sc_hd__o22a_1
X_1938_ net240 net53 VGND VGND VPWR VPWR _0027_ sky130_fd_sc_hd__nand2_1
XFILLER_29_223 VGND VGND VPWR VPWR sky130_fd_sc_hd__fill_1
XFILLER_29_201 VPWR VGND VPWR VGND sky130_ef_sc_hd__decap_12
XFILLER_8_105 VGND VGND VPWR VPWR sky130_fd_sc_hd__fill_1
XFILLER_12_156 VGND VGND VPWR VPWR sky130_fd_sc_hd__decap_8
XFILLER_12_167 VPWR VGND VPWR VGND sky130_ef_sc_hd__decap_12
XFILLER_35_237 VGND VGND VPWR VPWR sky130_fd_sc_hd__fill_1
XFILLER_43_281 VGND VGND VPWR VPWR sky130_fd_sc_hd__decap_6
X_1723_ _0822_ _0829_ _0836_ VGND VGND VPWR VPWR _0837_ sky130_fd_sc_hd__and3_4
X_1654_ net9 _0769_ net154 VGND VGND VPWR VPWR _0770_ sky130_fd_sc_hd__o21a_1
X_1585_ _0700_ _0702_ _0703_ net191 _0249_ VGND VGND VPWR VPWR _0704_ sky130_fd_sc_hd__a221o_1
X_2068_ net71 VGND VGND VPWR VPWR net97 sky130_fd_sc_hd__clkbuf_1
XFILLER_41_207 VGND VGND VPWR VPWR sky130_fd_sc_hd__fill_1
X_1019_ net1 VGND VGND VPWR VPWR _0089_ sky130_fd_sc_hd__inv_2
XFILLER_34_281 VGND VGND VPWR VPWR sky130_fd_sc_hd__decap_3
XFILLER_43_51 VGND VGND VPWR VPWR sky130_fd_sc_hd__decap_4
XFILLER_40_251 VGND VGND VPWR VPWR sky130_fd_sc_hd__fill_1
XTAP_TAPCELL_ROW_27_265 VGND VPWR sky130_fd_sc_hd__tapvpwrvgnd_1
XFILLER_27_85 VPWR VGND VPWR VGND sky130_ef_sc_hd__decap_12
XFILLER_25_281 VGND VGND VPWR VPWR sky130_fd_sc_hd__decap_4
X_1370_ _0474_ _0487_ _0496_ VGND VGND VPWR VPWR _0497_ sky130_fd_sc_hd__and3_1
XFILLER_31_273 VGND VGND VPWR VPWR sky130_fd_sc_hd__decap_6
XFILLER_31_240 VPWR VGND VPWR VGND sky130_ef_sc_hd__decap_12
X_1706_ _0819_ _0814_ VGND VGND VPWR VPWR _0820_ sky130_fd_sc_hd__xor2_1
X_1637_ _0751_ _0752_ net116 VGND VGND VPWR VPWR _0754_ sky130_fd_sc_hd__a21oi_1
XFILLER_48_29 VPWR VGND VPWR VGND sky130_ef_sc_hd__decap_12
XTAP_TAPCELL_ROW_1_122 VGND VPWR sky130_fd_sc_hd__tapvpwrvgnd_1
X_1499_ net229 net35 _0620_ VGND VGND VPWR VPWR _0621_ sky130_fd_sc_hd__a21o_1
X_1568_ _0249_ _0687_ _0677_ _0669_ VGND VGND VPWR VPWR _0688_ sky130_fd_sc_hd__o211a_1
XTAP_TAPCELL_ROW_24_246 VGND VPWR sky130_fd_sc_hd__tapvpwrvgnd_1
XTAP_TAPCELL_ROW_32_290 VGND VPWR sky130_fd_sc_hd__tapvpwrvgnd_1
XFILLER_13_65 VGND VGND VPWR VPWR sky130_fd_sc_hd__decap_4
XFILLER_1_111 VGND VGND VPWR VPWR sky130_fd_sc_hd__fill_1
XFILLER_1_144 VGND VGND VPWR VPWR sky130_fd_sc_hd__decap_6
XFILLER_8_3 VPWR VGND VPWR VGND sky130_ef_sc_hd__decap_12
XFILLER_9_277 VGND VGND VPWR VPWR sky130_fd_sc_hd__decap_3
XFILLER_13_262 VPWR VGND VPWR VGND sky130_ef_sc_hd__decap_12
X_1422_ net196 _0222_ VGND VGND VPWR VPWR _0547_ sky130_fd_sc_hd__nor2_1
XFILLER_9_299 VGND VGND VPWR VPWR sky130_fd_sc_hd__decap_4
X_1284_ _0215_ _0217_ net204 VGND VGND VPWR VPWR _0413_ sky130_fd_sc_hd__mux2_1
XPHY_EDGE_ROW_50_Left_104 VGND VGND VPWR VPWR sky130_fd_sc_hd__decap_3
XTAP_TAPCELL_ROW_38_327 VGND VPWR sky130_fd_sc_hd__tapvpwrvgnd_1
X_1353_ net29 net231 net232 net233 net216 net211 VGND VGND VPWR VPWR _0480_ sky130_fd_sc_hd__mux4_1
XTAP_TAPCELL_ROW_46_371 VGND VPWR sky130_fd_sc_hd__tapvpwrvgnd_1
Xfanout245 net17 VGND VGND VPWR VPWR net245 sky130_fd_sc_hd__buf_2
Xfanout223 net224 VGND VGND VPWR VPWR net223 sky130_fd_sc_hd__buf_8
Xfanout201 net206 VGND VGND VPWR VPWR net201 sky130_fd_sc_hd__clkbuf_2
Xfanout212 net213 VGND VGND VPWR VPWR net212 sky130_fd_sc_hd__clkbuf_4
Xfanout234 net236 VGND VGND VPWR VPWR net234 sky130_fd_sc_hd__clkbuf_2
XFILLER_24_53 VGND VGND VPWR VPWR sky130_fd_sc_hd__fill_2
XFILLER_24_64 VGND VGND VPWR VPWR sky130_fd_sc_hd__decap_3
XFILLER_40_41 VGND VGND VPWR VPWR sky130_fd_sc_hd__decap_3
XFILLER_6_269 VGND VGND VPWR VPWR sky130_fd_sc_hd__decap_8
XFILLER_10_265 VPWR VGND VPWR VGND sky130_ef_sc_hd__decap_12
XFILLER_49_83 VGND VGND VPWR VPWR sky130_fd_sc_hd__fill_1
XFILLER_45_195 VGND VGND VPWR VPWR sky130_fd_sc_hd__decap_3
XFILLER_45_173 VGND VGND VPWR VPWR sky130_fd_sc_hd__fill_1
XTAP_TAPCELL_ROW_43_352 VGND VPWR sky130_fd_sc_hd__tapvpwrvgnd_1
XTAP_TAPCELL_ROW_35_308 VGND VPWR sky130_fd_sc_hd__tapvpwrvgnd_1
XFILLER_1_57 VPWR VGND VPWR VGND sky130_ef_sc_hd__decap_12
XFILLER_18_321 VGND VGND VPWR VPWR sky130_fd_sc_hd__fill_1
X_1971_ net112 _0685_ _0059_ VGND VGND VPWR VPWR _0060_ sky130_fd_sc_hd__a21oi_1
X_1405_ net63 net147 net142 _0529_ VGND VGND VPWR VPWR _0530_ sky130_fd_sc_hd__a211o_1
Xinput1 A[0] VGND VGND VPWR VPWR net1 sky130_fd_sc_hd__clkbuf_2
XFILLER_28_129 VGND VGND VPWR VPWR sky130_fd_sc_hd__decap_3
X_1198_ net214 net202 net234 _0328_ VGND VGND VPWR VPWR _0329_ sky130_fd_sc_hd__a31o_1
X_1336_ _0460_ _0461_ _0463_ _0058_ VGND VGND VPWR VPWR _0464_ sky130_fd_sc_hd__a31o_1
X_1267_ net233 net121 net141 _0394_ net128 VGND VGND VPWR VPWR _0397_ sky130_fd_sc_hd__o221a_1
XFILLER_35_74 VGND VGND VPWR VPWR sky130_fd_sc_hd__decap_6
XFILLER_27_195 VGND VGND VPWR VPWR sky130_fd_sc_hd__decap_8
XFILLER_51_51 VGND VGND VPWR VPWR sky130_fd_sc_hd__decap_4
XTAP_TAPCELL_ROW_40_333 VGND VPWR sky130_fd_sc_hd__tapvpwrvgnd_1
XFILLER_2_261 VPWR VGND VPWR VGND sky130_ef_sc_hd__decap_12
X_1121_ _0089_ _0110_ net161 _0253_ VGND VGND VPWR VPWR _0254_ sky130_fd_sc_hd__a22o_1
X_1052_ net66 net187 _0184_ VGND VGND VPWR VPWR _0185_ sky130_fd_sc_hd__nor3_1
X_1954_ net22 net157 _0040_ VGND VGND VPWR VPWR _0042_ sky130_fd_sc_hd__and3_1
XFILLER_33_187 VGND VGND VPWR VPWR sky130_fd_sc_hd__fill_2
XFILLER_33_154 VGND VGND VPWR VPWR sky130_fd_sc_hd__decap_6
X_1885_ net243 net51 VGND VGND VPWR VPWR _0992_ sky130_fd_sc_hd__nor2_1
X_1319_ net194 _0446_ _0443_ VGND VGND VPWR VPWR _0447_ sky130_fd_sc_hd__a21oi_1
XFILLER_8_309 VGND VGND VPWR VPWR sky130_fd_sc_hd__decap_3
XFILLER_12_316 VGND VGND VPWR VPWR sky130_fd_sc_hd__fill_2
XFILLER_24_187 VGND VGND VPWR VPWR sky130_fd_sc_hd__fill_1
XFILLER_21_98 VPWR VGND VPWR VGND sky130_ef_sc_hd__decap_12
XFILLER_47_202 VPWR VGND VPWR VGND sky130_ef_sc_hd__decap_12
XFILLER_15_165 VGND VGND VPWR VPWR sky130_fd_sc_hd__decap_3
XFILLER_15_187 VGND VGND VPWR VPWR sky130_fd_sc_hd__fill_1
X_1670_ net182 _0780_ _0785_ VGND VGND VPWR VPWR _0786_ sky130_fd_sc_hd__a21oi_1
XFILLER_23_3 VPWR VGND VPWR VGND sky130_ef_sc_hd__decap_12
X_1104_ net200 net195 VGND VGND VPWR VPWR _0237_ sky130_fd_sc_hd__nor2_2
X_1035_ net195 VGND VGND VPWR VPWR _0168_ sky130_fd_sc_hd__inv_4
XFILLER_38_213 VGND VGND VPWR VPWR sky130_fd_sc_hd__fill_1
X_1937_ net167 _0025_ net120 net240 VGND VGND VPWR VPWR _0026_ sky130_fd_sc_hd__o2bb2a_1
XFILLER_21_113 VGND VGND VPWR VPWR sky130_fd_sc_hd__decap_6
XFILLER_21_146 VPWR VGND VPWR VGND sky130_ef_sc_hd__decap_12
X_1868_ _0917_ _0975_ net179 VGND VGND VPWR VPWR _0976_ sky130_fd_sc_hd__mux2_1
X_1799_ net48 net149 net144 _0908_ VGND VGND VPWR VPWR _0909_ sky130_fd_sc_hd__a211o_1
XFILLER_29_279 VGND VGND VPWR VPWR sky130_fd_sc_hd__fill_1
XFILLER_29_213 VGND VGND VPWR VPWR sky130_fd_sc_hd__decap_3
XFILLER_44_227 VGND VGND VPWR VPWR sky130_fd_sc_hd__decap_6
XFILLER_8_139 VGND VGND VPWR VPWR sky130_fd_sc_hd__fill_1
X_1584_ _0377_ _0477_ _0515_ VGND VGND VPWR VPWR _0703_ sky130_fd_sc_hd__o21a_1
XFILLER_7_161 VGND VGND VPWR VPWR sky130_fd_sc_hd__fill_2
XPHY_EDGE_ROW_9_Right_9 VGND VGND VPWR VPWR sky130_fd_sc_hd__decap_3
X_1722_ _0831_ _0833_ _0835_ net125 VGND VGND VPWR VPWR _0836_ sky130_fd_sc_hd__a31o_1
XTAP_TAPCELL_ROW_13_185 VGND VPWR sky130_fd_sc_hd__tapvpwrvgnd_1
X_1653_ net41 net162 net140 _0768_ VGND VGND VPWR VPWR _0769_ sky130_fd_sc_hd__o211ai_1
X_2067_ net157 _0158_ _0091_ VGND VGND VPWR VPWR net105 sky130_fd_sc_hd__and3_1
X_1018_ net190 VGND VGND VPWR VPWR _0079_ sky130_fd_sc_hd__inv_2
XFILLER_27_53 VGND VGND VPWR VPWR sky130_fd_sc_hd__decap_3
XFILLER_17_205 VGND VGND VPWR VPWR sky130_fd_sc_hd__fill_1
XFILLER_40_285 VPWR VGND VPWR VGND sky130_ef_sc_hd__decap_12
XTAP_TAPCELL_ROW_27_266 VGND VPWR sky130_fd_sc_hd__tapvpwrvgnd_1
XFILLER_27_97 VPWR VGND VPWR VGND sky130_ef_sc_hd__decap_12
Xclone84 net223 VGND VGND VPWR VPWR net336 sky130_fd_sc_hd__clkbuf_1
XFILLER_4_164 VGND VGND VPWR VPWR sky130_fd_sc_hd__decap_4
XFILLER_4_197 VPWR VGND VPWR VGND sky130_ef_sc_hd__decap_12
XFILLER_23_208 VGND VGND VPWR VPWR sky130_fd_sc_hd__fill_1
XFILLER_31_252 VPWR VGND VPWR VGND sky130_ef_sc_hd__decap_12
X_1705_ _0171_ _0817_ _0818_ VGND VGND VPWR VPWR _0819_ sky130_fd_sc_hd__o21ai_1
X_1567_ net192 _0681_ _0686_ VGND VGND VPWR VPWR _0687_ sky130_fd_sc_hd__a21oi_1
X_1636_ net142 _0752_ net131 VGND VGND VPWR VPWR _0753_ sky130_fd_sc_hd__a21o_1
XTAP_TAPCELL_ROW_1_123 VGND VPWR sky130_fd_sc_hd__tapvpwrvgnd_1
X_1498_ net139 _0619_ net128 VGND VGND VPWR VPWR _0620_ sky130_fd_sc_hd__o21a_1
XTAP_TAPCELL_ROW_24_247 VGND VPWR sky130_fd_sc_hd__tapvpwrvgnd_1
XTAP_TAPCELL_ROW_32_291 VGND VPWR sky130_fd_sc_hd__tapvpwrvgnd_1
XFILLER_38_41 VGND VGND VPWR VPWR sky130_fd_sc_hd__decap_6
XFILLER_1_123 VGND VGND VPWR VPWR sky130_fd_sc_hd__fill_2
XFILLER_38_85 VGND VGND VPWR VPWR sky130_fd_sc_hd__decap_4
XFILLER_9_212 VGND VGND VPWR VPWR sky130_fd_sc_hd__decap_3
XFILLER_9_234 VGND VGND VPWR VPWR sky130_fd_sc_hd__decap_3
XFILLER_13_274 VGND VGND VPWR VPWR sky130_fd_sc_hd__decap_6
X_1421_ _0216_ _0230_ net174 VGND VGND VPWR VPWR _0546_ sky130_fd_sc_hd__mux2_1
X_1352_ net194 _0477_ _0478_ net255 VGND VGND VPWR VPWR _0479_ sky130_fd_sc_hd__a211o_1
X_1283_ _0408_ _0409_ net122 VGND VGND VPWR VPWR _0412_ sky130_fd_sc_hd__a21oi_1
Xfanout246 net16 VGND VGND VPWR VPWR net246 sky130_fd_sc_hd__buf_2
Xfanout213 net214 VGND VGND VPWR VPWR net213 sky130_fd_sc_hd__buf_4
Xfanout235 net236 VGND VGND VPWR VPWR net235 sky130_fd_sc_hd__buf_1
X_1619_ net171 _0373_ VGND VGND VPWR VPWR _0737_ sky130_fd_sc_hd__nor2_1
Xfanout224 net33 VGND VGND VPWR VPWR net224 sky130_fd_sc_hd__buf_8
Xfanout202 net206 VGND VGND VPWR VPWR net202 sky130_fd_sc_hd__buf_2
XFILLER_39_193 VGND VGND VPWR VPWR sky130_fd_sc_hd__fill_1
XFILLER_10_277 VGND VGND VPWR VPWR sky130_fd_sc_hd__fill_1
XFILLER_24_21 VGND VGND VPWR VPWR sky130_fd_sc_hd__decap_6
XFILLER_40_97 VGND VGND VPWR VPWR sky130_fd_sc_hd__decap_4
XFILLER_49_51 VGND VGND VPWR VPWR sky130_fd_sc_hd__decap_4
XPHY_EDGE_ROW_39_Left_93 VGND VGND VPWR VPWR sky130_fd_sc_hd__decap_3
XFILLER_37_119 VGND VGND VPWR VPWR sky130_fd_sc_hd__fill_1
XFILLER_1_69 VPWR VGND VPWR VGND sky130_ef_sc_hd__decap_12
XTAP_TAPCELL_ROW_43_353 VGND VPWR sky130_fd_sc_hd__tapvpwrvgnd_1
X_1970_ net182 _0681_ _0057_ _0548_ VGND VGND VPWR VPWR _0059_ sky130_fd_sc_hd__a211o_1
XTAP_TAPCELL_ROW_35_309 VGND VPWR sky130_fd_sc_hd__tapvpwrvgnd_1
XPHY_EDGE_ROW_23_Left_77 VGND VGND VPWR VPWR sky130_fd_sc_hd__decap_3
X_1404_ net63 net159 VGND VGND VPWR VPWR _0529_ sky130_fd_sc_hd__nor2_1
X_1335_ net231 net118 _0457_ net159 _0462_ VGND VGND VPWR VPWR _0463_ sky130_fd_sc_hd__o221a_1
Xinput2 A[10] VGND VGND VPWR VPWR net2 sky130_fd_sc_hd__buf_1
XFILLER_51_111 VGND VGND VPWR VPWR sky130_fd_sc_hd__fill_1
XFILLER_36_185 VGND VGND VPWR VPWR sky130_fd_sc_hd__fill_1
X_1197_ _0327_ _0326_ net202 VGND VGND VPWR VPWR _0328_ sky130_fd_sc_hd__mux2_2
X_1266_ net115 _0359_ _0394_ _0395_ VGND VGND VPWR VPWR _0396_ sky130_fd_sc_hd__o2bb2ai_1
XTAP_TAPCELL_ROW_40_334 VGND VPWR sky130_fd_sc_hd__tapvpwrvgnd_1
XFILLER_2_273 VGND VGND VPWR VPWR sky130_fd_sc_hd__decap_4
XFILLER_2_251 VGND VGND VPWR VPWR sky130_fd_sc_hd__fill_1
X_1120_ net143 _0252_ VGND VGND VPWR VPWR _0253_ sky130_fd_sc_hd__nand2_1
X_1051_ net186 net185 net65 VGND VGND VPWR VPWR _0184_ sky130_fd_sc_hd__a21bo_4
X_1953_ net22 _0040_ net157 VGND VGND VPWR VPWR _0041_ sky130_fd_sc_hd__o21a_1
XFILLER_33_199 VGND VGND VPWR VPWR sky130_fd_sc_hd__decap_6
XFILLER_33_144 VGND VGND VPWR VPWR sky130_fd_sc_hd__fill_1
X_1884_ _0990_ _0989_ VGND VGND VPWR VPWR _0991_ sky130_fd_sc_hd__nand2_1
X_1318_ _0287_ net234 net202 VGND VGND VPWR VPWR _0446_ sky130_fd_sc_hd__mux2_1
X_1249_ net246 net17 net244 net243 net222 net213 VGND VGND VPWR VPWR _0379_ sky130_fd_sc_hd__mux4_1
XFILLER_47_214 VGND VGND VPWR VPWR sky130_fd_sc_hd__decap_8
XFILLER_46_41 VPWR VGND VPWR VGND sky130_ef_sc_hd__decap_12
XFILLER_30_147 VGND VGND VPWR VPWR sky130_fd_sc_hd__fill_1
XFILLER_7_35 VGND VGND VPWR VPWR sky130_fd_sc_hd__fill_1
XFILLER_16_3 VPWR VGND VPWR VGND sky130_ef_sc_hd__decap_12
X_1103_ net238 net233 net218 VGND VGND VPWR VPWR _0236_ sky130_fd_sc_hd__mux2_1
X_1034_ net183 VGND VGND VPWR VPWR _0167_ sky130_fd_sc_hd__inv_2
X_1867_ net244 net17 net222 VGND VGND VPWR VPWR _0975_ sky130_fd_sc_hd__mux2_1
X_1936_ net240 net53 VGND VGND VPWR VPWR _0025_ sky130_fd_sc_hd__or2_1
XPHY_EDGE_ROW_26_Left_80 VGND VGND VPWR VPWR sky130_fd_sc_hd__decap_3
XFILLER_21_169 VGND VGND VPWR VPWR sky130_fd_sc_hd__fill_1
Xinput60 B[5] VGND VGND VPWR VPWR net60 sky130_fd_sc_hd__buf_1
X_1798_ net48 net163 VGND VGND VPWR VPWR _0908_ sky130_fd_sc_hd__nor2_1
XPHY_EDGE_ROW_10_Left_64 VGND VGND VPWR VPWR sky130_fd_sc_hd__decap_3
XFILLER_44_217 VGND VGND VPWR VPWR sky130_fd_sc_hd__fill_1
XFILLER_12_147 VGND VGND VPWR VPWR sky130_fd_sc_hd__decap_3
XFILLER_16_33 VGND VGND VPWR VPWR sky130_fd_sc_hd__fill_1
XFILLER_16_66 VGND VGND VPWR VPWR sky130_fd_sc_hd__fill_1
XFILLER_32_43 VGND VGND VPWR VPWR sky130_fd_sc_hd__fill_1
XFILLER_20_180 VGND VGND VPWR VPWR sky130_fd_sc_hd__decap_4
XFILLER_43_261 VGND VGND VPWR VPWR sky130_fd_sc_hd__decap_3
XFILLER_35_206 VGND VGND VPWR VPWR sky130_fd_sc_hd__decap_3
XFILLER_43_294 VGND VGND VPWR VPWR sky130_fd_sc_hd__decap_6
X_1721_ net251 net43 net108 _0834_ VGND VGND VPWR VPWR _0835_ sky130_fd_sc_hd__a31o_1
XTAP_TAPCELL_ROW_13_186 VGND VPWR sky130_fd_sc_hd__tapvpwrvgnd_1
X_1583_ net190 _0701_ _0190_ VGND VGND VPWR VPWR _0702_ sky130_fd_sc_hd__o21ai_1
X_1652_ net41 net150 VGND VGND VPWR VPWR _0768_ sky130_fd_sc_hd__nand2_1
XFILLER_26_206 VGND VGND VPWR VPWR sky130_fd_sc_hd__decap_4
X_2066_ net236 _0086_ VGND VGND VPWR VPWR _0158_ sky130_fd_sc_hd__xnor2_1
X_1017_ net184 VGND VGND VPWR VPWR _0068_ sky130_fd_sc_hd__inv_4
X_1919_ _0241_ _0918_ _0008_ net171 VGND VGND VPWR VPWR _0009_ sky130_fd_sc_hd__o22a_1
XFILLER_1_305 VPWR VGND VPWR VGND sky130_ef_sc_hd__decap_12
XFILLER_43_75 VGND VGND VPWR VPWR sky130_fd_sc_hd__fill_1
XFILLER_40_297 VGND VGND VPWR VPWR sky130_fd_sc_hd__decap_8
XFILLER_40_253 VPWR VGND VPWR VGND sky130_ef_sc_hd__decap_12
XFILLER_25_294 VPWR VGND VPWR VGND sky130_ef_sc_hd__decap_12
XTAP_TAPCELL_ROW_18_212 VGND VPWR sky130_fd_sc_hd__tapvpwrvgnd_1
XFILLER_31_264 VGND VGND VPWR VPWR sky130_fd_sc_hd__fill_1
X_1704_ net251 _0816_ net154 VGND VGND VPWR VPWR _0818_ sky130_fd_sc_hd__o21a_1
X_1566_ net111 _0678_ _0685_ net114 VGND VGND VPWR VPWR _0686_ sky130_fd_sc_hd__a22o_1
X_1497_ net229 net35 VGND VGND VPWR VPWR _0619_ sky130_fd_sc_hd__nor2_1
X_1635_ net8 net40 VGND VGND VPWR VPWR _0752_ sky130_fd_sc_hd__or2_1
X_2049_ _0118_ _0141_ VGND VGND VPWR VPWR _0142_ sky130_fd_sc_hd__xnor2_1
XFILLER_14_209 VGND VGND VPWR VPWR sky130_fd_sc_hd__decap_8
XTAP_TAPCELL_ROW_32_292 VGND VPWR sky130_fd_sc_hd__tapvpwrvgnd_1
XFILLER_22_231 VGND VGND VPWR VPWR sky130_fd_sc_hd__fill_1
XFILLER_22_275 VGND VGND VPWR VPWR sky130_fd_sc_hd__fill_1
XFILLER_22_286 VGND VGND VPWR VPWR sky130_fd_sc_hd__decap_3
XTAP_TAPCELL_ROW_24_248 VGND VPWR sky130_fd_sc_hd__tapvpwrvgnd_1
XFILLER_45_301 VPWR VGND VPWR VGND sky130_ef_sc_hd__decap_12
XFILLER_9_202 VGND VGND VPWR VPWR sky130_fd_sc_hd__fill_2
X_1420_ _0245_ _0544_ net174 VGND VGND VPWR VPWR _0545_ sky130_fd_sc_hd__mux2_1
X_1351_ net194 _0475_ VGND VGND VPWR VPWR _0478_ sky130_fd_sc_hd__nor2_1
X_1282_ net66 net188 _0181_ VGND VGND VPWR VPWR _0411_ sky130_fd_sc_hd__a21o_1
XTAP_TAPCELL_ROW_21_229 VGND VPWR sky130_fd_sc_hd__tapvpwrvgnd_1
X_1618_ _0511_ _0735_ net173 VGND VGND VPWR VPWR _0736_ sky130_fd_sc_hd__mux2_1
Xfanout247 net15 VGND VGND VPWR VPWR net247 sky130_fd_sc_hd__clkbuf_4
Xfanout225 net32 VGND VGND VPWR VPWR net225 sky130_fd_sc_hd__clkbuf_4
Xfanout236 net25 VGND VGND VPWR VPWR net236 sky130_fd_sc_hd__dlymetal6s2s_1
Xfanout203 net204 VGND VGND VPWR VPWR net203 sky130_fd_sc_hd__clkbuf_4
Xfanout214 net44 VGND VGND VPWR VPWR net214 sky130_fd_sc_hd__buf_4
X_1549_ _0667_ _0668_ net122 VGND VGND VPWR VPWR _0669_ sky130_fd_sc_hd__a21o_1
XFILLER_1_15 VPWR VGND VPWR VGND sky130_ef_sc_hd__decap_12
XTAP_TAPCELL_ROW_43_354 VGND VPWR sky130_fd_sc_hd__tapvpwrvgnd_1
XFILLER_46_3 VPWR VGND VPWR VGND sky130_ef_sc_hd__decap_12
X_1403_ _0160_ _0501_ _0502_ _0498_ VGND VGND VPWR VPWR _0528_ sky130_fd_sc_hd__a2bb2o_4
X_1334_ net135 _0457_ _0459_ net142 VGND VGND VPWR VPWR _0462_ sky130_fd_sc_hd__a22oi_1
XPHY_EDGE_ROW_18_Right_18 VGND VGND VPWR VPWR sky130_fd_sc_hd__decap_3
X_1265_ net233 net193 VGND VGND VPWR VPWR _0395_ sky130_fd_sc_hd__and2_1
Xinput3 A[11] VGND VGND VPWR VPWR net3 sky130_fd_sc_hd__buf_1
X_1196_ net243 net241 net240 net239 net223 net212 VGND VGND VPWR VPWR _0327_ sky130_fd_sc_hd__mux4_2
XPHY_EDGE_ROW_27_Right_27 VGND VGND VPWR VPWR sky130_fd_sc_hd__decap_3
XFILLER_51_178 VGND VGND VPWR VPWR sky130_fd_sc_hd__decap_6
XFILLER_51_167 VGND VGND VPWR VPWR sky130_fd_sc_hd__fill_1
XPHY_EDGE_ROW_36_Right_36 VGND VGND VPWR VPWR sky130_fd_sc_hd__decap_3
XPHY_EDGE_ROW_40_Left_94 VGND VGND VPWR VPWR sky130_fd_sc_hd__decap_3
XFILLER_27_153 VGND VGND VPWR VPWR sky130_fd_sc_hd__fill_2
XFILLER_19_99 VGND VGND VPWR VPWR sky130_fd_sc_hd__decap_3
XPHY_EDGE_ROW_45_Right_45 VGND VGND VPWR VPWR sky130_fd_sc_hd__decap_3
XTAP_TAPCELL_ROW_40_335 VGND VPWR sky130_fd_sc_hd__tapvpwrvgnd_1
XFILLER_27_164 VGND VGND VPWR VPWR sky130_fd_sc_hd__decap_4
XFILLER_18_197 VGND VGND VPWR VPWR sky130_fd_sc_hd__decap_4
X_1050_ net185 net186 VGND VGND VPWR VPWR _0183_ sky130_fd_sc_hd__nand2_8
X_1952_ net54 net150 net145 _0039_ VGND VGND VPWR VPWR _0040_ sky130_fd_sc_hd__a211o_1
X_1883_ net51 net137 net130 _0176_ VGND VGND VPWR VPWR _0990_ sky130_fd_sc_hd__o2bb2a_1
XFILLER_21_307 VGND VGND VPWR VPWR sky130_fd_sc_hd__decap_4
XPHY_EDGE_ROW_47_Left_101 VGND VGND VPWR VPWR sky130_fd_sc_hd__decap_3
X_1248_ net251 net249 net14 net247 net336 net213 VGND VGND VPWR VPWR _0378_ sky130_fd_sc_hd__mux4_1
X_1317_ _0443_ _0444_ net167 VGND VGND VPWR VPWR _0445_ sky130_fd_sc_hd__o21ai_1
X_1179_ net191 _0294_ _0310_ VGND VGND VPWR VPWR _0311_ sky130_fd_sc_hd__a21oi_1
XFILLER_46_53 VGND VGND VPWR VPWR sky130_fd_sc_hd__decap_8
XFILLER_30_137 VGND VGND VPWR VPWR sky130_fd_sc_hd__decap_3
XFILLER_30_115 VGND VGND VPWR VPWR sky130_fd_sc_hd__decap_8
X_1102_ net208 _0232_ _0233_ VGND VGND VPWR VPWR _0235_ sky130_fd_sc_hd__o21ai_1
XFILLER_53_207 VGND VGND VPWR VPWR sky130_fd_sc_hd__fill_1
XFILLER_46_281 VGND VGND VPWR VPWR sky130_fd_sc_hd__decap_3
X_1033_ net189 VGND VGND VPWR VPWR _0166_ sky130_fd_sc_hd__inv_2
X_1935_ _0022_ _0023_ VGND VGND VPWR VPWR _0024_ sky130_fd_sc_hd__nand2_1
X_1797_ _0173_ _0888_ _0889_ _0885_ VGND VGND VPWR VPWR _0907_ sky130_fd_sc_hd__a2bb2o_4
Xinput50 B[25] VGND VGND VPWR VPWR net50 sky130_fd_sc_hd__buf_1
Xinput61 B[6] VGND VGND VPWR VPWR net61 sky130_fd_sc_hd__dlymetal6s2s_1
X_1866_ net181 _0571_ VGND VGND VPWR VPWR _0974_ sky130_fd_sc_hd__and2_1
XFILLER_37_281 VPWR VGND VPWR VGND sky130_ef_sc_hd__decap_12
XFILLER_29_259 VPWR VGND VPWR VGND sky130_ef_sc_hd__decap_12
XFILLER_29_237 VGND VGND VPWR VPWR sky130_fd_sc_hd__decap_4
XPHY_EDGE_ROW_0_Right_0 VGND VGND VPWR VPWR sky130_fd_sc_hd__decap_3
XTAP_TAPCELL_ROW_7_152 VGND VPWR sky130_fd_sc_hd__tapvpwrvgnd_1
XFILLER_43_273 VGND VGND VPWR VPWR sky130_fd_sc_hd__decap_6
XFILLER_28_270 VGND VGND VPWR VPWR sky130_fd_sc_hd__fill_1
X_1720_ net140 _0830_ _0832_ net129 VGND VGND VPWR VPWR _0834_ sky130_fd_sc_hd__o211a_1
XTAP_TAPCELL_ROW_13_187 VGND VPWR sky130_fd_sc_hd__tapvpwrvgnd_1
X_1651_ _0169_ _0745_ _0746_ _0742_ VGND VGND VPWR VPWR _0767_ sky130_fd_sc_hd__a2bb2o_4
X_1582_ _0475_ _0484_ net173 VGND VGND VPWR VPWR _0701_ sky130_fd_sc_hd__mux2_1
XFILLER_7_185 VGND VGND VPWR VPWR sky130_fd_sc_hd__fill_1
X_2065_ net236 net157 _0088_ _0092_ VGND VGND VPWR VPWR net70 sky130_fd_sc_hd__a31o_1
XFILLER_34_273 VGND VGND VPWR VPWR sky130_fd_sc_hd__decap_8
XFILLER_34_251 VGND VGND VPWR VPWR sky130_fd_sc_hd__fill_1
X_1016_ net254 VGND VGND VPWR VPWR _0058_ sky130_fd_sc_hd__inv_2
X_1918_ _0975_ _0007_ net179 VGND VGND VPWR VPWR _0008_ sky130_fd_sc_hd__mux2_1
X_1849_ _0936_ _0933_ _0937_ VGND VGND VPWR VPWR _0957_ sky130_fd_sc_hd__a21o_1
XFILLER_1_317 VGND VGND VPWR VPWR sky130_fd_sc_hd__decap_4
XFILLER_40_265 VPWR VGND VPWR VGND sky130_ef_sc_hd__decap_12
Xclone20 net188 VGND VGND VPWR VPWR net272 sky130_fd_sc_hd__clkbuf_1
XFILLER_4_15 VPWR VGND VPWR VGND sky130_ef_sc_hd__decap_12
XTAP_TAPCELL_ROW_10_168 VGND VPWR sky130_fd_sc_hd__tapvpwrvgnd_1
XTAP_TAPCELL_ROW_18_213 VGND VPWR sky130_fd_sc_hd__tapvpwrvgnd_1
XFILLER_16_295 VGND VGND VPWR VPWR sky130_fd_sc_hd__decap_4
X_1703_ net154 _0816_ VGND VGND VPWR VPWR _0817_ sky130_fd_sc_hd__nand2_1
X_1634_ net8 net40 VGND VGND VPWR VPWR _0751_ sky130_fd_sc_hd__nand2_1
X_1565_ _0450_ _0683_ _0298_ _0574_ net174 net201 VGND VGND VPWR VPWR _0685_ sky130_fd_sc_hd__mux4_1
X_1496_ _0164_ net108 net35 VGND VGND VPWR VPWR _0618_ sky130_fd_sc_hd__or3b_1
X_2048_ _0120_ _0140_ VGND VGND VPWR VPWR _0141_ sky130_fd_sc_hd__xnor2_1
XTAP_TAPCELL_ROW_32_293 VGND VPWR sky130_fd_sc_hd__tapvpwrvgnd_1
XTAP_TAPCELL_ROW_24_249 VGND VPWR sky130_fd_sc_hd__tapvpwrvgnd_1
XFILLER_13_254 VGND VGND VPWR VPWR sky130_fd_sc_hd__fill_2
X_1350_ _0219_ _0369_ _0476_ VGND VGND VPWR VPWR _0477_ sky130_fd_sc_hd__mux2_1
X_1281_ net66 net188 _0181_ VGND VGND VPWR VPWR _0410_ sky130_fd_sc_hd__a21oi_2
XFILLER_51_305 VGND VGND VPWR VPWR sky130_fd_sc_hd__decap_8
XFILLER_48_195 VGND VGND VPWR VPWR sky130_fd_sc_hd__fill_1
X_1617_ _0734_ _0629_ net205 VGND VGND VPWR VPWR _0735_ sky130_fd_sc_hd__mux2_1
Xfanout204 net205 VGND VGND VPWR VPWR net204 sky130_fd_sc_hd__buf_2
Xfanout248 net14 VGND VGND VPWR VPWR net248 sky130_fd_sc_hd__buf_2
Xfanout215 net4 VGND VGND VPWR VPWR net215 sky130_fd_sc_hd__buf_2
Xfanout226 net32 VGND VGND VPWR VPWR net226 sky130_fd_sc_hd__buf_1
Xfanout237 net24 VGND VGND VPWR VPWR net237 sky130_fd_sc_hd__clkbuf_2
X_1479_ net2 net226 net31 net30 net33 net211 VGND VGND VPWR VPWR _0602_ sky130_fd_sc_hd__mux4_1
X_1548_ net37 net135 net128 _0165_ VGND VGND VPWR VPWR _0668_ sky130_fd_sc_hd__o2bb2a_1
XTAP_TAPCELL_ROW_52_399 VGND VPWR sky130_fd_sc_hd__tapvpwrvgnd_1
XFILLER_10_213 VPWR VGND VPWR VGND sky130_ef_sc_hd__decap_12
XFILLER_1_27 VPWR VGND VPWR VGND sky130_ef_sc_hd__decap_12
X_1402_ net169 _0527_ VGND VGND VPWR VPWR net102 sky130_fd_sc_hd__nor2_1
Xinput4 A[12] VGND VGND VPWR VPWR net4 sky130_fd_sc_hd__buf_1
XFILLER_39_3 VPWR VGND VPWR VGND sky130_ef_sc_hd__decap_12
X_1333_ net127 _0458_ VGND VGND VPWR VPWR _0461_ sky130_fd_sc_hd__or2_1
X_1264_ net233 net193 VGND VGND VPWR VPWR _0394_ sky130_fd_sc_hd__nor2_1
XFILLER_51_113 VGND VGND VPWR VPWR sky130_fd_sc_hd__decap_4
XFILLER_36_154 VGND VGND VPWR VPWR sky130_fd_sc_hd__decap_6
XFILLER_36_121 VGND VGND VPWR VPWR sky130_fd_sc_hd__fill_1
XTAP_TAPCELL_ROW_34_300 VGND VPWR sky130_fd_sc_hd__tapvpwrvgnd_1
X_1195_ net214 _0219_ VGND VGND VPWR VPWR _0326_ sky130_fd_sc_hd__nor2_1
XFILLER_24_305 VGND VGND VPWR VPWR sky130_fd_sc_hd__decap_3
XFILLER_15_305 VGND VGND VPWR VPWR sky130_fd_sc_hd__fill_2
XTAP_TAPCELL_ROW_40_336 VGND VPWR sky130_fd_sc_hd__tapvpwrvgnd_1
XFILLER_35_88 VGND VGND VPWR VPWR sky130_fd_sc_hd__fill_1
XFILLER_30_319 VGND VGND VPWR VPWR sky130_fd_sc_hd__decap_3
XFILLER_2_253 VGND VGND VPWR VPWR sky130_fd_sc_hd__fill_1
XFILLER_33_179 VGND VGND VPWR VPWR sky130_fd_sc_hd__fill_1
XFILLER_18_165 VGND VGND VPWR VPWR sky130_fd_sc_hd__decap_3
X_1951_ net54 net164 VGND VGND VPWR VPWR _0039_ sky130_fd_sc_hd__nor2_1
X_1882_ _0983_ _0988_ VGND VGND VPWR VPWR _0989_ sky130_fd_sc_hd__xor2_1
X_1178_ net111 _0309_ _0301_ VGND VGND VPWR VPWR _0310_ sky130_fd_sc_hd__a21o_1
X_1247_ net193 net117 VGND VGND VPWR VPWR _0377_ sky130_fd_sc_hd__or2_1
X_1316_ net202 net194 _0287_ _0291_ VGND VGND VPWR VPWR _0444_ sky130_fd_sc_hd__and4b_1
XFILLER_15_113 VPWR VGND VPWR VGND sky130_ef_sc_hd__decap_12
XFILLER_7_15 VPWR VGND VPWR VGND sky130_ef_sc_hd__decap_12
XFILLER_15_179 VGND VGND VPWR VPWR sky130_fd_sc_hd__decap_4
X_1101_ _0233_ VGND VGND VPWR VPWR _0234_ sky130_fd_sc_hd__inv_2
X_1032_ net207 VGND VGND VPWR VPWR _0165_ sky130_fd_sc_hd__inv_2
X_1934_ net53 net138 net132 net240 VGND VGND VPWR VPWR _0023_ sky130_fd_sc_hd__a22oi_1
XFILLER_21_127 VGND VGND VPWR VPWR sky130_fd_sc_hd__fill_1
X_1796_ net125 _0905_ _0906_ VGND VGND VPWR VPWR net87 sky130_fd_sc_hd__o21bai_4
Xinput51 B[26] VGND VGND VPWR VPWR net51 sky130_fd_sc_hd__dlymetal6s2s_1
Xinput62 B[7] VGND VGND VPWR VPWR net62 sky130_fd_sc_hd__buf_1
Xinput40 B[16] VGND VGND VPWR VPWR net40 sky130_fd_sc_hd__dlymetal6s2s_1
X_1865_ _0969_ _0971_ _0972_ net125 VGND VGND VPWR VPWR _0973_ sky130_fd_sc_hd__a31oi_1
XFILLER_37_293 VGND VGND VPWR VPWR sky130_fd_sc_hd__decap_3
XFILLER_12_116 VGND VGND VPWR VPWR sky130_fd_sc_hd__fill_1
XTAP_TAPCELL_ROW_7_153 VGND VPWR sky130_fd_sc_hd__tapvpwrvgnd_1
X_1581_ _0359_ _0482_ _0699_ _0344_ VGND VGND VPWR VPWR _0700_ sky130_fd_sc_hd__a2bb2oi_1
X_1650_ _0766_ VGND VGND VPWR VPWR net80 sky130_fd_sc_hd__inv_2
XTAP_TAPCELL_ROW_13_188 VGND VPWR sky130_fd_sc_hd__tapvpwrvgnd_1
XFILLER_21_3 VPWR VGND VPWR VGND sky130_ef_sc_hd__decap_12
X_2064_ net93 net94 _0108_ _0157_ VGND VGND VPWR VPWR net106 sky130_fd_sc_hd__and4bb_1
XFILLER_34_241 VGND VGND VPWR VPWR sky130_fd_sc_hd__fill_2
XFILLER_19_271 VGND VGND VPWR VPWR sky130_fd_sc_hd__fill_2
X_1917_ net20 net19 net222 VGND VGND VPWR VPWR _0007_ sky130_fd_sc_hd__mux2_1
X_1848_ _0956_ VGND VGND VPWR VPWR net89 sky130_fd_sc_hd__inv_4
X_1779_ _0173_ _0888_ _0889_ VGND VGND VPWR VPWR _0890_ sky130_fd_sc_hd__o21ai_1
XFILLER_43_55 VGND VGND VPWR VPWR sky130_fd_sc_hd__fill_1
XFILLER_40_233 VPWR VGND VPWR VGND sky130_ef_sc_hd__decap_12
XFILLER_25_285 VGND VGND VPWR VPWR sky130_fd_sc_hd__fill_1
XTAP_TAPCELL_ROW_10_169 VGND VPWR sky130_fd_sc_hd__tapvpwrvgnd_1
XFILLER_4_27 VGND VGND VPWR VPWR sky130_fd_sc_hd__fill_1
XTAP_TAPCELL_ROW_18_214 VGND VPWR sky130_fd_sc_hd__tapvpwrvgnd_1
XFILLER_31_288 VGND VGND VPWR VPWR sky130_fd_sc_hd__fill_1
X_1564_ _0683_ _0574_ net200 VGND VGND VPWR VPWR _0684_ sky130_fd_sc_hd__mux2_1
X_1702_ net43 net149 net144 _0815_ VGND VGND VPWR VPWR _0816_ sky130_fd_sc_hd__a211o_1
X_1633_ _0749_ _0748_ VGND VGND VPWR VPWR _0750_ sky130_fd_sc_hd__nand2_1
X_1495_ _0616_ _0615_ net122 VGND VGND VPWR VPWR _0617_ sky130_fd_sc_hd__a21o_1
XTAP_TAPCELL_ROW_49_383 VGND VPWR sky130_fd_sc_hd__tapvpwrvgnd_1
X_2047_ _0122_ _0139_ VGND VGND VPWR VPWR _0140_ sky130_fd_sc_hd__xnor2_1
XTAP_TAPCELL_ROW_32_294 VGND VPWR sky130_fd_sc_hd__tapvpwrvgnd_1
XFILLER_13_47 VGND VGND VPWR VPWR sky130_fd_sc_hd__decap_3
XFILLER_38_77 VGND VGND VPWR VPWR sky130_fd_sc_hd__decap_6
XFILLER_0_192 VGND VGND VPWR VPWR sky130_fd_sc_hd__decap_4
X_1280_ net181 net134 net128 _0143_ VGND VGND VPWR VPWR _0409_ sky130_fd_sc_hd__o22a_1
XFILLER_48_185 VGND VGND VPWR VPWR sky130_fd_sc_hd__fill_1
XFILLER_36_303 VGND VGND VPWR VPWR sky130_fd_sc_hd__decap_4
Xfanout227 net31 VGND VGND VPWR VPWR net227 sky130_fd_sc_hd__buf_2
Xfanout238 net23 VGND VGND VPWR VPWR net238 sky130_fd_sc_hd__buf_2
X_1616_ _0682_ _0733_ net178 VGND VGND VPWR VPWR _0734_ sky130_fd_sc_hd__mux2_1
Xfanout205 net206 VGND VGND VPWR VPWR net205 sky130_fd_sc_hd__clkbuf_4
X_1547_ net259 _0666_ VGND VGND VPWR VPWR _0667_ sky130_fd_sc_hd__xor2_1
Xfanout216 net33 VGND VGND VPWR VPWR net216 sky130_fd_sc_hd__buf_2
Xfanout249 net13 VGND VGND VPWR VPWR net249 sky130_fd_sc_hd__buf_2
X_1478_ net242 net226 net219 VGND VGND VPWR VPWR _0601_ sky130_fd_sc_hd__mux2_1
XFILLER_39_185 VGND VGND VPWR VPWR sky130_fd_sc_hd__decap_8
XFILLER_39_141 VPWR VGND VPWR VGND sky130_ef_sc_hd__decap_12
XFILLER_39_130 VGND VGND VPWR VPWR sky130_fd_sc_hd__decap_3
XTAP_TAPCELL_ROW_37_320 VGND VPWR sky130_fd_sc_hd__tapvpwrvgnd_1
XFILLER_10_225 VPWR VGND VPWR VGND sky130_ef_sc_hd__decap_12
XFILLER_6_229 VPWR VGND VPWR VGND sky130_ef_sc_hd__decap_12
XFILLER_49_65 VGND VGND VPWR VPWR sky130_fd_sc_hd__fill_1
XFILLER_45_111 VGND VGND VPWR VPWR sky130_fd_sc_hd__fill_1
XFILLER_1_39 VPWR VGND VPWR VGND sky130_ef_sc_hd__decap_12
XFILLER_5_284 VPWR VGND VPWR VGND sky130_ef_sc_hd__decap_12
XFILLER_5_251 VPWR VGND VPWR VGND sky130_ef_sc_hd__decap_12
X_1401_ _0513_ _0518_ _0526_ _0506_ VGND VGND VPWR VPWR _0527_ sky130_fd_sc_hd__o211a_1
Xinput5 A[13] VGND VGND VPWR VPWR net5 sky130_fd_sc_hd__clkbuf_1
X_1194_ net175 _0324_ VGND VGND VPWR VPWR _0325_ sky130_fd_sc_hd__and2_4
X_1263_ net190 _0381_ _0392_ _0249_ VGND VGND VPWR VPWR _0393_ sky130_fd_sc_hd__a211o_1
X_1332_ net115 _0434_ _0459_ VGND VGND VPWR VPWR _0460_ sky130_fd_sc_hd__a21o_1
XTAP_TAPCELL_ROW_34_301 VGND VPWR sky130_fd_sc_hd__tapvpwrvgnd_1
XFILLER_10_15 VPWR VGND VPWR VGND sky130_ef_sc_hd__decap_12
XFILLER_27_144 VGND VGND VPWR VPWR sky130_fd_sc_hd__fill_1
XFILLER_51_77 VGND VGND VPWR VPWR sky130_fd_sc_hd__decap_8
XFILLER_51_55 VGND VGND VPWR VPWR sky130_fd_sc_hd__fill_1
XFILLER_50_191 VGND VGND VPWR VPWR sky130_fd_sc_hd__decap_4
XTAP_TAPCELL_ROW_40_337 VGND VPWR sky130_fd_sc_hd__tapvpwrvgnd_1
X_1950_ _0018_ _0015_ _0020_ VGND VGND VPWR VPWR _0038_ sky130_fd_sc_hd__a21o_1
XFILLER_33_169 VGND VGND VPWR VPWR sky130_fd_sc_hd__decap_6
X_1881_ _0176_ _0986_ _0987_ VGND VGND VPWR VPWR _0988_ sky130_fd_sc_hd__o21ai_1
XFILLER_51_3 VPWR VGND VPWR VGND sky130_ef_sc_hd__decap_12
X_1315_ net176 _0442_ VGND VGND VPWR VPWR _0443_ sky130_fd_sc_hd__and2_1
XFILLER_49_291 VPWR VGND VPWR VGND sky130_ef_sc_hd__decap_12
X_1177_ _0304_ _0308_ net195 VGND VGND VPWR VPWR _0309_ sky130_fd_sc_hd__mux2_1
X_1246_ _0370_ _0375_ net172 VGND VGND VPWR VPWR _0376_ sky130_fd_sc_hd__a21oi_2
XFILLER_24_103 VGND VGND VPWR VPWR sky130_fd_sc_hd__fill_1
XFILLER_15_125 VPWR VGND VPWR VGND sky130_ef_sc_hd__decap_12
XFILLER_15_169 VGND VGND VPWR VPWR sky130_fd_sc_hd__decap_6
XFILLER_7_27 VGND VGND VPWR VPWR sky130_fd_sc_hd__decap_8
XFILLER_23_191 VGND VGND VPWR VPWR sky130_fd_sc_hd__fill_2
X_1100_ _0089_ net217 net208 VGND VGND VPWR VPWR _0233_ sky130_fd_sc_hd__or3_2
X_1031_ net229 VGND VGND VPWR VPWR _0164_ sky130_fd_sc_hd__inv_2
X_1933_ _0015_ _0021_ VGND VGND VPWR VPWR _0022_ sky130_fd_sc_hd__xnor2_1
Xinput30 A[7] VGND VGND VPWR VPWR net30 sky130_fd_sc_hd__buf_1
X_1795_ _0248_ _0898_ _0899_ _0893_ net124 VGND VGND VPWR VPWR _0906_ sky130_fd_sc_hd__a32o_1
Xinput52 B[27] VGND VGND VPWR VPWR net52 sky130_fd_sc_hd__clkbuf_2
Xinput63 B[8] VGND VGND VPWR VPWR net63 sky130_fd_sc_hd__buf_1
Xinput41 B[17] VGND VGND VPWR VPWR net41 sky130_fd_sc_hd__buf_1
X_1864_ net244 net119 _0207_ _0967_ _0968_ VGND VGND VPWR VPWR _0972_ sky130_fd_sc_hd__o221a_1
X_1229_ net193 net148 VGND VGND VPWR VPWR _0359_ sky130_fd_sc_hd__nand2_1
XFILLER_32_35 VGND VGND VPWR VPWR sky130_fd_sc_hd__fill_1
XFILLER_20_172 VGND VGND VPWR VPWR sky130_fd_sc_hd__fill_2
XTAP_TAPCELL_ROW_7_154 VGND VPWR sky130_fd_sc_hd__tapvpwrvgnd_1
XFILLER_28_250 VGND VGND VPWR VPWR sky130_fd_sc_hd__fill_2
XFILLER_43_220 VGND VGND VPWR VPWR sky130_fd_sc_hd__decap_4
XFILLER_28_294 VGND VGND VPWR VPWR sky130_fd_sc_hd__decap_6
X_1580_ _0698_ _0602_ net199 VGND VGND VPWR VPWR _0699_ sky130_fd_sc_hd__mux2_1
XFILLER_7_132 VPWR VGND VPWR VGND sky130_ef_sc_hd__decap_12
XFILLER_7_198 VPWR VGND VPWR VGND sky130_ef_sc_hd__decap_12
XFILLER_11_183 VGND VGND VPWR VPWR sky130_fd_sc_hd__fill_2
XTAP_TAPCELL_ROW_13_189 VGND VPWR sky130_fd_sc_hd__tapvpwrvgnd_1
XFILLER_14_3 VPWR VGND VPWR VGND sky130_ef_sc_hd__decap_12
X_2063_ net85 _0156_ net86 _0115_ VGND VGND VPWR VPWR _0157_ sky130_fd_sc_hd__nor4b_2
XFILLER_34_253 VGND VGND VPWR VPWR sky130_fd_sc_hd__decap_4
XPHY_EDGE_ROW_14_Left_68 VGND VGND VPWR VPWR sky130_fd_sc_hd__decap_3
X_1916_ net241 net120 _0002_ net164 _0005_ VGND VGND VPWR VPWR _0006_ sky130_fd_sc_hd__o221a_1
X_1847_ _0948_ _0942_ _0955_ net169 VGND VGND VPWR VPWR _0956_ sky130_fd_sc_hd__a31o_4
X_1778_ net247 _0887_ net155 VGND VGND VPWR VPWR _0889_ sky130_fd_sc_hd__o21a_1
XTAP_TAPCELL_ROW_4_135 VGND VPWR sky130_fd_sc_hd__tapvpwrvgnd_1
XFILLER_40_245 VGND VGND VPWR VPWR sky130_fd_sc_hd__decap_6
XFILLER_27_79 VGND VGND VPWR VPWR sky130_fd_sc_hd__fill_1
XFILLER_25_264 VGND VGND VPWR VPWR sky130_fd_sc_hd__decap_4
XTAP_TAPCELL_ROW_18_215 VGND VPWR sky130_fd_sc_hd__tapvpwrvgnd_1
XFILLER_31_223 VGND VGND VPWR VPWR sky130_fd_sc_hd__fill_1
X_1701_ net43 net162 VGND VGND VPWR VPWR _0815_ sky130_fd_sc_hd__nor2_1
X_1563_ _0628_ _0682_ net180 VGND VGND VPWR VPWR _0683_ sky130_fd_sc_hd__mux2_1
X_1494_ net35 net135 net127 _0164_ VGND VGND VPWR VPWR _0616_ sky130_fd_sc_hd__o2bb2a_1
X_1632_ net40 net136 net128 _0169_ VGND VGND VPWR VPWR _0749_ sky130_fd_sc_hd__o2bb2a_1
XTAP_TAPCELL_ROW_49_384 VGND VPWR sky130_fd_sc_hd__tapvpwrvgnd_1
XFILLER_13_15 VPWR VGND VPWR VGND sky130_ef_sc_hd__decap_12
X_2046_ _0124_ _0138_ VGND VGND VPWR VPWR _0139_ sky130_fd_sc_hd__xnor2_1
XFILLER_9_249 VGND VGND VPWR VPWR sky130_fd_sc_hd__decap_4
XTAP_TAPCELL_ROW_23_240 VGND VPWR sky130_fd_sc_hd__tapvpwrvgnd_1
XFILLER_48_120 VGND VGND VPWR VPWR sky130_fd_sc_hd__decap_8
XFILLER_0_182 VGND VGND VPWR VPWR sky130_fd_sc_hd__decap_6
Xfanout228 net30 VGND VGND VPWR VPWR net228 sky130_fd_sc_hd__buf_2
Xfanout239 net22 VGND VGND VPWR VPWR net239 sky130_fd_sc_hd__buf_2
X_1615_ net183 net6 net220 VGND VGND VPWR VPWR _0733_ sky130_fd_sc_hd__mux2_1
X_1477_ net174 _0324_ _0599_ net111 VGND VGND VPWR VPWR _0600_ sky130_fd_sc_hd__o211a_1
Xfanout217 net219 VGND VGND VPWR VPWR net217 sky130_fd_sc_hd__clkbuf_4
Xfanout206 net55 VGND VGND VPWR VPWR net206 sky130_fd_sc_hd__clkbuf_2
X_1546_ _0165_ _0664_ _0665_ VGND VGND VPWR VPWR _0666_ sky130_fd_sc_hd__o21ai_1
XFILLER_39_153 VGND VGND VPWR VPWR sky130_fd_sc_hd__fill_2
XTAP_TAPCELL_ROW_37_321 VGND VPWR sky130_fd_sc_hd__tapvpwrvgnd_1
X_2029_ _0766_ _0790_ _0119_ VGND VGND VPWR VPWR _0120_ sky130_fd_sc_hd__o21ai_1
XFILLER_6_208 VPWR VGND VPWR VGND sky130_ef_sc_hd__decap_12
XFILLER_10_237 VPWR VGND VPWR VGND sky130_ef_sc_hd__decap_12
XFILLER_10_259 VGND VGND VPWR VPWR sky130_fd_sc_hd__decap_3
XPHY_EDGE_ROW_17_Left_71 VGND VGND VPWR VPWR sky130_fd_sc_hd__decap_3
XFILLER_49_77 VGND VGND VPWR VPWR sky130_fd_sc_hd__decap_6
XFILLER_49_55 VGND VGND VPWR VPWR sky130_fd_sc_hd__fill_1
XFILLER_5_230 VGND VGND VPWR VPWR sky130_fd_sc_hd__decap_8
XFILLER_5_296 VPWR VGND VPWR VGND sky130_ef_sc_hd__decap_12
XFILLER_5_263 VPWR VGND VPWR VGND sky130_ef_sc_hd__decap_12
X_1400_ _0522_ _0523_ _0525_ _0058_ VGND VGND VPWR VPWR _0526_ sky130_fd_sc_hd__a31o_1
X_1331_ _0457_ _0458_ VGND VGND VPWR VPWR _0459_ sky130_fd_sc_hd__nor2_1
Xinput6 A[14] VGND VGND VPWR VPWR net6 sky130_fd_sc_hd__buf_1
X_1193_ _0322_ _0323_ net205 VGND VGND VPWR VPWR _0324_ sky130_fd_sc_hd__mux2_2
X_1262_ _0345_ _0389_ _0391_ _0189_ _0226_ VGND VGND VPWR VPWR _0392_ sky130_fd_sc_hd__o221a_1
XTAP_TAPCELL_ROW_34_302 VGND VPWR sky130_fd_sc_hd__tapvpwrvgnd_1
XFILLER_10_27 VGND VGND VPWR VPWR sky130_fd_sc_hd__fill_1
X_1529_ net215 net118 net134 _0645_ _0646_ VGND VGND VPWR VPWR _0650_ sky130_fd_sc_hd__o221a_1
XFILLER_35_68 VGND VGND VPWR VPWR sky130_fd_sc_hd__fill_1
XTAP_TAPCELL_ROW_40_338 VGND VPWR sky130_fd_sc_hd__tapvpwrvgnd_1
XPHY_EDGE_ROW_2_Left_56 VGND VGND VPWR VPWR sky130_fd_sc_hd__decap_3
XPHY_EDGE_ROW_14_Right_14 VGND VGND VPWR VPWR sky130_fd_sc_hd__decap_3
XFILLER_2_277 VGND VGND VPWR VPWR sky130_fd_sc_hd__fill_1
XPHY_EDGE_ROW_23_Right_23 VGND VGND VPWR VPWR sky130_fd_sc_hd__decap_3
XFILLER_18_112 VGND VGND VPWR VPWR sky130_fd_sc_hd__decap_8
XFILLER_41_181 VGND VGND VPWR VPWR sky130_fd_sc_hd__decap_6
XPHY_EDGE_ROW_32_Right_32 VGND VGND VPWR VPWR sky130_fd_sc_hd__decap_3
X_1880_ net243 _0985_ net156 VGND VGND VPWR VPWR _0987_ sky130_fd_sc_hd__o21a_1
X_1314_ _0281_ _0284_ net203 VGND VGND VPWR VPWR _0442_ sky130_fd_sc_hd__mux2_1
XFILLER_44_3 VPWR VGND VPWR VGND sky130_ef_sc_hd__decap_12
XPHY_EDGE_ROW_41_Right_41 VGND VGND VPWR VPWR sky130_fd_sc_hd__decap_3
X_1176_ _0305_ _0307_ net205 VGND VGND VPWR VPWR _0308_ sky130_fd_sc_hd__mux2_1
XPHY_EDGE_ROW_50_Right_50 VGND VGND VPWR VPWR sky130_fd_sc_hd__decap_3
X_1245_ net202 net120 _0372_ _0374_ net165 VGND VGND VPWR VPWR _0375_ sky130_fd_sc_hd__o32a_4
XFILLER_2_83 VGND VGND VPWR VPWR sky130_fd_sc_hd__fill_1
XFILLER_24_148 VGND VGND VPWR VPWR sky130_fd_sc_hd__decap_4
XPHY_EDGE_ROW_44_Left_98 VGND VGND VPWR VPWR sky130_fd_sc_hd__decap_3
XFILLER_32_181 VGND VGND VPWR VPWR sky130_fd_sc_hd__decap_8
XFILLER_21_15 VPWR VGND VPWR VGND sky130_ef_sc_hd__decap_12
XFILLER_30_129 VGND VGND VPWR VPWR sky130_fd_sc_hd__decap_8
XFILLER_15_104 VGND VGND VPWR VPWR sky130_fd_sc_hd__decap_8
XFILLER_15_137 VGND VGND VPWR VPWR sky130_fd_sc_hd__decap_8
XFILLER_11_81 VPWR VGND VPWR VGND sky130_ef_sc_hd__decap_12
XFILLER_46_273 VGND VGND VPWR VPWR sky130_fd_sc_hd__decap_8
XFILLER_46_262 VGND VGND VPWR VPWR sky130_fd_sc_hd__fill_2
X_1030_ net242 VGND VGND VPWR VPWR _0163_ sky130_fd_sc_hd__inv_2
Xinput20 A[27] VGND VGND VPWR VPWR net20 sky130_fd_sc_hd__buf_1
Xinput31 A[8] VGND VGND VPWR VPWR net31 sky130_fd_sc_hd__buf_1
X_1932_ _0019_ _0020_ VGND VGND VPWR VPWR _0021_ sky130_fd_sc_hd__nor2_1
X_1863_ _0966_ _0970_ VGND VGND VPWR VPWR _0971_ sky130_fd_sc_hd__nand2_1
Xinput53 B[28] VGND VGND VPWR VPWR net53 sky130_fd_sc_hd__clkbuf_2
Xinput64 B[9] VGND VGND VPWR VPWR net64 sky130_fd_sc_hd__dlymetal6s2s_1
Xinput42 B[18] VGND VGND VPWR VPWR net42 sky130_fd_sc_hd__clkbuf_2
X_1794_ net247 net119 _0903_ _0904_ VGND VGND VPWR VPWR _0905_ sky130_fd_sc_hd__o211a_1
XFILLER_37_240 VPWR VGND VPWR VGND sky130_ef_sc_hd__decap_12
X_1228_ net172 net146 VGND VGND VPWR VPWR _0358_ sky130_fd_sc_hd__nor2_1
X_1159_ net224 _0290_ VGND VGND VPWR VPWR _0291_ sky130_fd_sc_hd__nand2_1
XFILLER_16_15 VPWR VGND VPWR VGND sky130_ef_sc_hd__decap_12
XFILLER_4_306 VGND VGND VPWR VPWR sky130_fd_sc_hd__fill_2
XFILLER_20_195 VGND VGND VPWR VPWR sky130_fd_sc_hd__fill_1
XTAP_TAPCELL_ROW_7_155 VGND VPWR sky130_fd_sc_hd__tapvpwrvgnd_1
XFILLER_43_210 VGND VGND VPWR VPWR sky130_fd_sc_hd__decap_3
XFILLER_7_144 VGND VGND VPWR VPWR sky130_fd_sc_hd__fill_2
XFILLER_7_166 VGND VGND VPWR VPWR sky130_fd_sc_hd__fill_2
X_2062_ net91 net92 _0113_ _0155_ VGND VGND VPWR VPWR _0156_ sky130_fd_sc_hd__or4_4
XFILLER_34_287 VPWR VGND VPWR VGND sky130_ef_sc_hd__decap_12
X_1915_ net241 net52 net110 _0001_ _0004_ VGND VGND VPWR VPWR _0005_ sky130_fd_sc_hd__o311a_1
X_1777_ net155 _0887_ VGND VGND VPWR VPWR _0888_ sky130_fd_sc_hd__nand2_1
X_1846_ net184 _0954_ VGND VGND VPWR VPWR _0955_ sky130_fd_sc_hd__nand2_1
XPHY_EDGE_ROW_4_Right_4 VGND VGND VPWR VPWR sky130_fd_sc_hd__decap_3
XTAP_TAPCELL_ROW_4_136 VGND VPWR sky130_fd_sc_hd__tapvpwrvgnd_1
XFILLER_43_57 VPWR VGND VPWR VGND sky130_ef_sc_hd__decap_12
XFILLER_40_224 VGND VGND VPWR VPWR sky130_fd_sc_hd__decap_3
XFILLER_4_114 VPWR VGND VPWR VGND sky130_ef_sc_hd__decap_12
XFILLER_4_29 VPWR VGND VPWR VGND sky130_ef_sc_hd__decap_12
XPHY_EDGE_ROW_31_Left_85 VGND VGND VPWR VPWR sky130_fd_sc_hd__decap_3
XTAP_TAPCELL_ROW_26_260 VGND VPWR sky130_fd_sc_hd__tapvpwrvgnd_1
XTAP_TAPCELL_ROW_18_216 VGND VPWR sky130_fd_sc_hd__tapvpwrvgnd_1
XFILLER_31_279 VGND VGND VPWR VPWR sky130_fd_sc_hd__fill_1
X_1631_ net274 _0747_ VGND VGND VPWR VPWR _0748_ sky130_fd_sc_hd__xor2_1
X_1700_ net252 _0180_ _0795_ _0792_ _0797_ VGND VGND VPWR VPWR _0814_ sky130_fd_sc_hd__a32o_2
X_1562_ net207 net4 net219 VGND VGND VPWR VPWR _0682_ sky130_fd_sc_hd__mux2_1
X_1493_ _0614_ _0609_ VGND VGND VPWR VPWR _0615_ sky130_fd_sc_hd__xor2_1
XTAP_TAPCELL_ROW_49_385 VGND VPWR sky130_fd_sc_hd__tapvpwrvgnd_1
X_2045_ _0125_ _0137_ VGND VGND VPWR VPWR _0138_ sky130_fd_sc_hd__xnor2_1
XFILLER_13_27 VPWR VGND VPWR VGND sky130_ef_sc_hd__decap_12
X_1829_ _0937_ VGND VGND VPWR VPWR _0938_ sky130_fd_sc_hd__inv_2
XTAP_TAPCELL_ROW_23_241 VGND VPWR sky130_fd_sc_hd__tapvpwrvgnd_1
XFILLER_48_154 VGND VGND VPWR VPWR sky130_fd_sc_hd__decap_3
XFILLER_48_110 VGND VGND VPWR VPWR sky130_fd_sc_hd__fill_2
XFILLER_28_90 VGND VGND VPWR VPWR sky130_fd_sc_hd__fill_2
XFILLER_0_161 VGND VGND VPWR VPWR sky130_fd_sc_hd__decap_6
XTAP_TAPCELL_ROW_46_366 VGND VPWR sky130_fd_sc_hd__tapvpwrvgnd_1
X_1614_ _0507_ _0514_ net197 VGND VGND VPWR VPWR _0732_ sky130_fd_sc_hd__mux2_1
Xfanout207 net5 VGND VGND VPWR VPWR net207 sky130_fd_sc_hd__buf_2
Xfanout229 net3 VGND VGND VPWR VPWR net229 sky130_fd_sc_hd__clkbuf_4
X_1476_ net196 _0335_ VGND VGND VPWR VPWR _0599_ sky130_fd_sc_hd__or2_1
Xfanout218 net219 VGND VGND VPWR VPWR net218 sky130_fd_sc_hd__buf_2
X_1545_ net207 _0663_ net152 VGND VGND VPWR VPWR _0665_ sky130_fd_sc_hd__o21a_1
XFILLER_39_165 VGND VGND VPWR VPWR sky130_fd_sc_hd__decap_3
X_2028_ _0766_ _0791_ VGND VGND VPWR VPWR _0119_ sky130_fd_sc_hd__nand2_1
XFILLER_10_249 VGND VGND VPWR VPWR sky130_fd_sc_hd__decap_3
XFILLER_24_59 VGND VGND VPWR VPWR sky130_fd_sc_hd__fill_1
XFILLER_40_69 VGND VGND VPWR VPWR sky130_fd_sc_hd__decap_6
XFILLER_45_113 VGND VGND VPWR VPWR sky130_fd_sc_hd__decap_4
XFILLER_14_81 VGND VGND VPWR VPWR sky130_fd_sc_hd__decap_3
X_1261_ net196 _0384_ _0387_ VGND VGND VPWR VPWR _0391_ sky130_fd_sc_hd__a21oi_1
XFILLER_5_275 VGND VGND VPWR VPWR sky130_fd_sc_hd__decap_4
X_1330_ net231 net60 VGND VGND VPWR VPWR _0458_ sky130_fd_sc_hd__and2_1
Xinput7 A[15] VGND VGND VPWR VPWR net7 sky130_fd_sc_hd__clkbuf_1
X_1192_ net247 net246 net245 net244 net221 net212 VGND VGND VPWR VPWR _0323_ sky130_fd_sc_hd__mux4_2
XFILLER_36_168 VGND VGND VPWR VPWR sky130_fd_sc_hd__fill_2
XTAP_TAPCELL_ROW_34_303 VGND VPWR sky130_fd_sc_hd__tapvpwrvgnd_1
XFILLER_51_138 VGND VGND VPWR VPWR sky130_fd_sc_hd__fill_2
XFILLER_44_190 VGND VGND VPWR VPWR sky130_fd_sc_hd__decap_6
XFILLER_27_113 VPWR VGND VPWR VGND sky130_ef_sc_hd__decap_12
X_1459_ net34 net159 VGND VGND VPWR VPWR _0582_ sky130_fd_sc_hd__nor2_1
X_1528_ _0644_ _0648_ VGND VGND VPWR VPWR _0649_ sky130_fd_sc_hd__nand2_1
XFILLER_19_15 VPWR VGND VPWR VGND sky130_ef_sc_hd__decap_12
XFILLER_51_57 VPWR VGND VPWR VGND sky130_ef_sc_hd__decap_12
XFILLER_4_3 VPWR VGND VPWR VGND sky130_ef_sc_hd__decap_12
XFILLER_33_116 VPWR VGND VPWR VGND sky130_ef_sc_hd__decap_12
XFILLER_18_157 VGND VGND VPWR VPWR sky130_fd_sc_hd__decap_8
XFILLER_25_91 VGND VGND VPWR VPWR sky130_fd_sc_hd__fill_2
XFILLER_37_3 VPWR VGND VPWR VGND sky130_ef_sc_hd__decap_12
X_1244_ _0372_ _0373_ net202 VGND VGND VPWR VPWR _0374_ sky130_fd_sc_hd__mux2_1
X_1313_ _0439_ _0440_ net122 VGND VGND VPWR VPWR _0441_ sky130_fd_sc_hd__a21o_1
X_1175_ net207 net189 net183 net8 net220 net213 VGND VGND VPWR VPWR _0307_ sky130_fd_sc_hd__mux4_1
XFILLER_24_138 VGND VGND VPWR VPWR sky130_fd_sc_hd__fill_2
XFILLER_11_93 VPWR VGND VPWR VGND sky130_ef_sc_hd__decap_12
Xinput21 A[28] VGND VGND VPWR VPWR net21 sky130_fd_sc_hd__buf_1
Xinput10 A[18] VGND VGND VPWR VPWR net10 sky130_fd_sc_hd__buf_1
Xinput32 A[9] VGND VGND VPWR VPWR net32 sky130_fd_sc_hd__clkbuf_1
X_1931_ net240 net157 _0017_ VGND VGND VPWR VPWR _0020_ sky130_fd_sc_hd__and3_1
Xinput54 B[29] VGND VGND VPWR VPWR net54 sky130_fd_sc_hd__clkbuf_2
Xinput43 B[19] VGND VGND VPWR VPWR net43 sky130_fd_sc_hd__clkbuf_2
X_1793_ net163 net110 _0900_ VGND VGND VPWR VPWR _0904_ sky130_fd_sc_hd__mux2_1
XFILLER_14_193 VGND VGND VPWR VPWR sky130_fd_sc_hd__decap_3
X_1862_ net144 _0967_ net132 VGND VGND VPWR VPWR _0970_ sky130_fd_sc_hd__a21o_1
Xinput65 alu_opcode[0] VGND VGND VPWR VPWR net65 sky130_fd_sc_hd__dlymetal6s2s_1
XFILLER_37_252 VGND VGND VPWR VPWR sky130_fd_sc_hd__decap_4
X_1158_ _0110_ net214 net237 VGND VGND VPWR VPWR _0290_ sky130_fd_sc_hd__or3b_1
XFILLER_29_219 VGND VGND VPWR VPWR sky130_fd_sc_hd__decap_4
X_1227_ net233 net153 VGND VGND VPWR VPWR _0357_ sky130_fd_sc_hd__nand2_1
XFILLER_52_299 VGND VGND VPWR VPWR sky130_fd_sc_hd__decap_8
X_1089_ net203 _0220_ _0221_ VGND VGND VPWR VPWR _0222_ sky130_fd_sc_hd__a21oi_2
XFILLER_32_15 VPWR VGND VPWR VGND sky130_ef_sc_hd__decap_12
XFILLER_16_27 VGND VGND VPWR VPWR sky130_fd_sc_hd__fill_1
XFILLER_20_141 VGND VGND VPWR VPWR sky130_fd_sc_hd__fill_2
XTAP_TAPCELL_ROW_7_156 VGND VPWR sky130_fd_sc_hd__tapvpwrvgnd_1
XPHY_EDGE_ROW_53_Left_107 VGND VGND VPWR VPWR sky130_fd_sc_hd__decap_3
X_2061_ net82 net83 _0119_ _0154_ VGND VGND VPWR VPWR _0155_ sky130_fd_sc_hd__or4_1
XFILLER_34_222 VGND VGND VPWR VPWR sky130_fd_sc_hd__fill_1
X_1914_ net241 net52 _0003_ VGND VGND VPWR VPWR _0004_ sky130_fd_sc_hd__a21o_1
X_1845_ net112 _0545_ _0949_ _0953_ VGND VGND VPWR VPWR _0954_ sky130_fd_sc_hd__a211o_1
X_1776_ net47 net149 net144 _0886_ VGND VGND VPWR VPWR _0887_ sky130_fd_sc_hd__a211o_1
XFILLER_8_50 VPWR VGND VPWR VGND sky130_ef_sc_hd__decap_12
XFILLER_8_83 VGND VGND VPWR VPWR sky130_fd_sc_hd__fill_1
XTAP_TAPCELL_ROW_12_180 VGND VPWR sky130_fd_sc_hd__tapvpwrvgnd_1
XTAP_TAPCELL_ROW_4_137 VGND VPWR sky130_fd_sc_hd__tapvpwrvgnd_1
XFILLER_27_15 VPWR VGND VPWR VGND sky130_ef_sc_hd__decap_12
XFILLER_43_69 VGND VGND VPWR VPWR sky130_fd_sc_hd__decap_6
XFILLER_4_126 VPWR VGND VPWR VGND sky130_ef_sc_hd__decap_12
XFILLER_4_104 VGND VGND VPWR VPWR sky130_fd_sc_hd__decap_3
XFILLER_31_225 VGND VGND VPWR VPWR sky130_fd_sc_hd__fill_2
XTAP_TAPCELL_ROW_26_261 VGND VPWR sky130_fd_sc_hd__tapvpwrvgnd_1
XFILLER_16_266 VGND VGND VPWR VPWR sky130_fd_sc_hd__decap_3
XTAP_TAPCELL_ROW_18_217 VGND VPWR sky130_fd_sc_hd__tapvpwrvgnd_1
X_1630_ _0169_ _0745_ _0746_ VGND VGND VPWR VPWR _0747_ sky130_fd_sc_hd__o21ai_1
X_1561_ _0624_ _0680_ VGND VGND VPWR VPWR _0681_ sky130_fd_sc_hd__nand2_1
X_1492_ _0164_ _0612_ _0613_ VGND VGND VPWR VPWR _0614_ sky130_fd_sc_hd__o21ai_1
XTAP_TAPCELL_ROW_49_386 VGND VPWR sky130_fd_sc_hd__tapvpwrvgnd_1
X_2044_ _0126_ _0136_ VGND VGND VPWR VPWR _0137_ sky130_fd_sc_hd__xnor2_1
XFILLER_13_39 VGND VGND VPWR VPWR sky130_fd_sc_hd__fill_1
X_1759_ net14 net13 net336 VGND VGND VPWR VPWR _0871_ sky130_fd_sc_hd__mux2_1
X_1828_ net245 net156 _0935_ VGND VGND VPWR VPWR _0937_ sky130_fd_sc_hd__and3_1
XFILLER_21_291 VGND VGND VPWR VPWR sky130_fd_sc_hd__decap_4
XTAP_TAPCELL_ROW_23_242 VGND VPWR sky130_fd_sc_hd__tapvpwrvgnd_1
XFILLER_48_177 VGND VGND VPWR VPWR sky130_fd_sc_hd__decap_8
XFILLER_48_166 VGND VGND VPWR VPWR sky130_fd_sc_hd__fill_2
XTAP_TAPCELL_ROW_46_367 VGND VPWR sky130_fd_sc_hd__tapvpwrvgnd_1
XFILLER_5_51 VGND VGND VPWR VPWR sky130_fd_sc_hd__decap_4
X_1544_ net152 _0663_ VGND VGND VPWR VPWR _0664_ sky130_fd_sc_hd__nand2_1
XFILLER_8_251 VGND VGND VPWR VPWR sky130_fd_sc_hd__fill_1
X_1613_ _0727_ _0728_ _0730_ VGND VGND VPWR VPWR _0731_ sky130_fd_sc_hd__and3_1
Xfanout208 net210 VGND VGND VPWR VPWR net208 sky130_fd_sc_hd__clkbuf_4
Xfanout219 net33 VGND VGND VPWR VPWR net219 sky130_fd_sc_hd__clkbuf_4
X_1475_ net172 net256 _0328_ _0360_ VGND VGND VPWR VPWR _0598_ sky130_fd_sc_hd__a22o_1
XFILLER_42_309 VGND VGND VPWR VPWR sky130_fd_sc_hd__decap_4
X_2027_ net83 net306 net82 VGND VGND VPWR VPWR _0118_ sky130_fd_sc_hd__mux2_1
XFILLER_24_27 VGND VGND VPWR VPWR sky130_fd_sc_hd__fill_1
XFILLER_40_15 VPWR VGND VPWR VGND sky130_ef_sc_hd__decap_12
XTAP_TAPCELL_ROW_20_223 VGND VPWR sky130_fd_sc_hd__tapvpwrvgnd_1
XFILLER_49_57 VGND VGND VPWR VPWR sky130_fd_sc_hd__decap_8
XFILLER_6_7 VPWR VGND VPWR VGND sky130_ef_sc_hd__decap_12
XFILLER_45_169 VGND VGND VPWR VPWR sky130_fd_sc_hd__decap_4
XFILLER_18_306 VGND VGND VPWR VPWR sky130_fd_sc_hd__fill_2
XFILLER_53_191 VGND VGND VPWR VPWR sky130_fd_sc_hd__fill_2
Xinput8 A[16] VGND VGND VPWR VPWR net8 sky130_fd_sc_hd__buf_2
X_1191_ _0212_ _0214_ net213 VGND VGND VPWR VPWR _0322_ sky130_fd_sc_hd__mux2_2
X_1260_ _0389_ VGND VGND VPWR VPWR _0390_ sky130_fd_sc_hd__inv_2
XFILLER_51_106 VGND VGND VPWR VPWR sky130_fd_sc_hd__fill_2
XTAP_TAPCELL_ROW_34_304 VGND VPWR sky130_fd_sc_hd__tapvpwrvgnd_1
XFILLER_24_309 VGND VGND VPWR VPWR sky130_fd_sc_hd__fill_1
XFILLER_10_29 VPWR VGND VPWR VGND sky130_ef_sc_hd__decap_12
X_1527_ net143 _0645_ net131 VGND VGND VPWR VPWR _0648_ sky130_fd_sc_hd__a21o_1
XFILLER_35_15 VPWR VGND VPWR VGND sky130_ef_sc_hd__decap_12
X_1389_ net194 _0368_ VGND VGND VPWR VPWR _0515_ sky130_fd_sc_hd__nand2_1
XFILLER_27_125 VGND VGND VPWR VPWR sky130_fd_sc_hd__decap_6
X_1458_ _0557_ _0554_ _0558_ VGND VGND VPWR VPWR _0581_ sky130_fd_sc_hd__a21o_1
XFILLER_19_27 VGND VGND VPWR VPWR sky130_fd_sc_hd__fill_2
XFILLER_42_139 VGND VGND VPWR VPWR sky130_fd_sc_hd__fill_1
XFILLER_27_169 VGND VGND VPWR VPWR sky130_fd_sc_hd__decap_4
XFILLER_51_69 VGND VGND VPWR VPWR sky130_fd_sc_hd__decap_4
XFILLER_33_128 VPWR VGND VPWR VGND sky130_ef_sc_hd__decap_12
X_1174_ net183 net8 net220 VGND VGND VPWR VPWR _0306_ sky130_fd_sc_hd__mux2_1
X_1243_ net224 net214 net234 VGND VGND VPWR VPWR _0373_ sky130_fd_sc_hd__or3b_1
XFILLER_2_96 VGND VGND VPWR VPWR sky130_fd_sc_hd__decap_8
XFILLER_2_41 VPWR VGND VPWR VGND sky130_ef_sc_hd__decap_12
X_1312_ net60 net135 net127 _0153_ VGND VGND VPWR VPWR _0440_ sky130_fd_sc_hd__o2bb2a_1
XFILLER_20_301 VGND VGND VPWR VPWR sky130_fd_sc_hd__fill_2
XTAP_TAPCELL_ROW_53_410 VGND VPWR sky130_fd_sc_hd__tapvpwrvgnd_1
XFILLER_7_305 VGND VGND VPWR VPWR sky130_fd_sc_hd__decap_8
XFILLER_46_297 VGND VGND VPWR VPWR sky130_fd_sc_hd__decap_8
X_1930_ _0018_ VGND VGND VPWR VPWR _0019_ sky130_fd_sc_hd__inv_2
Xinput22 A[29] VGND VGND VPWR VPWR net22 sky130_fd_sc_hd__buf_1
Xinput11 A[19] VGND VGND VPWR VPWR net11 sky130_fd_sc_hd__buf_1
Xinput66 alu_opcode[1] VGND VGND VPWR VPWR net66 sky130_fd_sc_hd__buf_2
Xinput33 B[0] VGND VGND VPWR VPWR net33 sky130_fd_sc_hd__buf_4
Xinput44 B[1] VGND VGND VPWR VPWR net44 sky130_fd_sc_hd__clkbuf_2
Xinput55 B[2] VGND VGND VPWR VPWR net55 sky130_fd_sc_hd__buf_1
X_1792_ net247 net47 _0260_ _0902_ VGND VGND VPWR VPWR _0903_ sky130_fd_sc_hd__a31o_1
X_1861_ net167 _0967_ _0966_ _0197_ VGND VGND VPWR VPWR _0969_ sky130_fd_sc_hd__o2bb2a_1
X_1157_ net193 _0288_ _0283_ VGND VGND VPWR VPWR _0289_ sky130_fd_sc_hd__a21boi_1
X_1226_ _0121_ _0316_ _0317_ _0313_ VGND VGND VPWR VPWR _0356_ sky130_fd_sc_hd__a2bb2o_4
X_1088_ net203 _0217_ VGND VGND VPWR VPWR _0221_ sky130_fd_sc_hd__and2b_1
XFILLER_32_27 VGND VGND VPWR VPWR sky130_fd_sc_hd__fill_1
XFILLER_28_220 VGND VGND VPWR VPWR sky130_fd_sc_hd__decap_8
XFILLER_28_275 VGND VGND VPWR VPWR sky130_fd_sc_hd__decap_4
X_2060_ net78 net79 _0152_ VGND VGND VPWR VPWR _0154_ sky130_fd_sc_hd__or3_1
X_1913_ net140 _0002_ net130 VGND VGND VPWR VPWR _0003_ sky130_fd_sc_hd__o21a_1
X_1844_ net174 _0761_ _0952_ net114 VGND VGND VPWR VPWR _0953_ sky130_fd_sc_hd__o211a_1
X_1775_ net47 net162 VGND VGND VPWR VPWR _0886_ sky130_fd_sc_hd__nor2_1
XFILLER_6_190 VGND VGND VPWR VPWR sky130_fd_sc_hd__decap_6
XFILLER_8_62 VGND VGND VPWR VPWR sky130_fd_sc_hd__fill_1
XTAP_TAPCELL_ROW_12_181 VGND VPWR sky130_fd_sc_hd__tapvpwrvgnd_1
XFILLER_27_27 VPWR VGND VPWR VGND sky130_ef_sc_hd__decap_12
XTAP_TAPCELL_ROW_4_138 VGND VPWR sky130_fd_sc_hd__tapvpwrvgnd_1
XFILLER_43_15 VPWR VGND VPWR VGND sky130_ef_sc_hd__decap_12
X_1209_ net216 _0121_ _0232_ VGND VGND VPWR VPWR _0340_ sky130_fd_sc_hd__o21ai_1
XFILLER_25_223 VGND VGND VPWR VPWR sky130_fd_sc_hd__fill_1
XFILLER_25_212 VGND VGND VPWR VPWR sky130_fd_sc_hd__decap_3
XFILLER_4_138 VGND VGND VPWR VPWR sky130_fd_sc_hd__fill_2
X_1560_ net255 _0679_ net171 _0287_ VGND VGND VPWR VPWR _0680_ sky130_fd_sc_hd__or4b_1
X_1491_ net229 _0611_ net152 VGND VGND VPWR VPWR _0613_ sky130_fd_sc_hd__o21a_1
XTAP_TAPCELL_ROW_49_387 VGND VPWR sky130_fd_sc_hd__tapvpwrvgnd_1
XTAP_TAPCELL_ROW_1_119 VGND VPWR sky130_fd_sc_hd__tapvpwrvgnd_1
X_2043_ _0128_ _0135_ VGND VGND VPWR VPWR _0136_ sky130_fd_sc_hd__xnor2_1
X_1827_ net245 _0935_ net156 VGND VGND VPWR VPWR _0936_ sky130_fd_sc_hd__o21a_1
X_1689_ _0603_ _0803_ net172 VGND VGND VPWR VPWR _0804_ sky130_fd_sc_hd__mux2_1
X_1758_ _0869_ _0868_ net123 VGND VGND VPWR VPWR _0870_ sky130_fd_sc_hd__a21o_1
XFILLER_38_15 VPWR VGND VPWR VGND sky130_ef_sc_hd__decap_12
XFILLER_13_204 VPWR VGND VPWR VGND sky130_ef_sc_hd__decap_12
XFILLER_13_237 VGND VGND VPWR VPWR sky130_fd_sc_hd__decap_3
XTAP_TAPCELL_ROW_23_243 VGND VPWR sky130_fd_sc_hd__tapvpwrvgnd_1
XFILLER_0_152 VGND VGND VPWR VPWR sky130_fd_sc_hd__decap_6
XTAP_TAPCELL_ROW_46_368 VGND VPWR sky130_fd_sc_hd__tapvpwrvgnd_1
XFILLER_36_307 VGND VGND VPWR VPWR sky130_fd_sc_hd__fill_1
XFILLER_28_81 VGND VGND VPWR VPWR sky130_fd_sc_hd__decap_3
XFILLER_12_281 VPWR VGND VPWR VGND sky130_ef_sc_hd__decap_12
Xfanout209 net210 VGND VGND VPWR VPWR net209 sky130_fd_sc_hd__clkbuf_2
XFILLER_5_85 VGND VGND VPWR VPWR sky130_fd_sc_hd__fill_1
X_1612_ net129 _0724_ _0725_ net162 _0729_ VGND VGND VPWR VPWR _0730_ sky130_fd_sc_hd__o221a_1
XFILLER_8_296 VGND VGND VPWR VPWR sky130_fd_sc_hd__decap_3
X_1543_ net37 net160 net139 _0662_ VGND VGND VPWR VPWR _0663_ sky130_fd_sc_hd__o211ai_1
X_1474_ _0592_ _0595_ _0596_ net254 VGND VGND VPWR VPWR _0597_ sky130_fd_sc_hd__o31a_1
XFILLER_50_321 VGND VGND VPWR VPWR sky130_fd_sc_hd__fill_1
X_2026_ net86 _0884_ net85 VGND VGND VPWR VPWR _0117_ sky130_fd_sc_hd__mux2_1
XFILLER_40_27 VGND VGND VPWR VPWR sky130_fd_sc_hd__fill_1
XTAP_TAPCELL_ROW_20_224 VGND VPWR sky130_fd_sc_hd__tapvpwrvgnd_1
XFILLER_45_137 VGND VGND VPWR VPWR sky130_fd_sc_hd__fill_1
XFILLER_30_82 VGND VGND VPWR VPWR sky130_fd_sc_hd__fill_2
XFILLER_30_60 VGND VGND VPWR VPWR sky130_fd_sc_hd__decap_3
Xinput9 A[17] VGND VGND VPWR VPWR net9 sky130_fd_sc_hd__buf_2
XFILLER_39_80 VGND VGND VPWR VPWR sky130_fd_sc_hd__decap_3
XFILLER_36_104 VGND VGND VPWR VPWR sky130_fd_sc_hd__fill_1
X_1190_ _0319_ _0320_ _0181_ VGND VGND VPWR VPWR _0321_ sky130_fd_sc_hd__a21oi_1
XTAP_TAPCELL_ROW_34_305 VGND VPWR sky130_fd_sc_hd__tapvpwrvgnd_1
X_1526_ net166 _0645_ _0644_ net146 VGND VGND VPWR VPWR _0647_ sky130_fd_sc_hd__o2bb2a_1
X_1457_ net169 _0580_ VGND VGND VPWR VPWR net104 sky130_fd_sc_hd__nor2_4
X_1388_ _0379_ _0371_ net204 VGND VGND VPWR VPWR _0514_ sky130_fd_sc_hd__mux2_1
XFILLER_35_38 VPWR VGND VPWR VGND sky130_ef_sc_hd__decap_12
XFILLER_35_27 VGND VGND VPWR VPWR sky130_fd_sc_hd__decap_8
XFILLER_51_15 VPWR VGND VPWR VGND sky130_ef_sc_hd__decap_12
XFILLER_50_195 VGND VGND VPWR VPWR sky130_fd_sc_hd__fill_1
XFILLER_50_162 VGND VGND VPWR VPWR sky130_fd_sc_hd__decap_8
XFILLER_35_181 VGND VGND VPWR VPWR sky130_fd_sc_hd__decap_8
X_2009_ _0403_ _0736_ _0737_ net182 _0368_ VGND VGND VPWR VPWR _0099_ sky130_fd_sc_hd__a221oi_1
XFILLER_25_71 VGND VGND VPWR VPWR sky130_fd_sc_hd__fill_1
X_1311_ _0433_ _0438_ VGND VGND VPWR VPWR _0439_ sky130_fd_sc_hd__xor2_1
X_1173_ net225 net242 net229 net215 net219 net210 VGND VGND VPWR VPWR _0305_ sky130_fd_sc_hd__mux4_1
X_1242_ _0371_ VGND VGND VPWR VPWR _0372_ sky130_fd_sc_hd__inv_2
XFILLER_2_53 VPWR VGND VPWR VGND sky130_ef_sc_hd__decap_12
XPHY_EDGE_ROW_10_Right_10 VGND VGND VPWR VPWR sky130_fd_sc_hd__decap_3
XFILLER_24_107 VPWR VGND VPWR VGND sky130_ef_sc_hd__decap_12
XFILLER_32_195 VGND VGND VPWR VPWR sky130_fd_sc_hd__fill_1
XFILLER_46_15 VPWR VGND VPWR VGND sky130_ef_sc_hd__decap_12
X_1509_ _0390_ _0630_ net175 VGND VGND VPWR VPWR _0631_ sky130_fd_sc_hd__mux2_1
XTAP_TAPCELL_ROW_53_411 VGND VPWR sky130_fd_sc_hd__tapvpwrvgnd_1
XFILLER_23_140 VPWR VGND VPWR VGND sky130_ef_sc_hd__decap_12
XFILLER_11_313 VGND VGND VPWR VPWR sky130_fd_sc_hd__fill_1
X_1860_ _0966_ _0967_ net116 VGND VGND VPWR VPWR _0968_ sky130_fd_sc_hd__a21o_1
Xinput23 A[2] VGND VGND VPWR VPWR net23 sky130_fd_sc_hd__buf_1
Xinput12 A[1] VGND VGND VPWR VPWR net12 sky130_fd_sc_hd__buf_1
Xinput56 B[30] VGND VGND VPWR VPWR net56 sky130_fd_sc_hd__clkbuf_2
Xinput45 B[20] VGND VGND VPWR VPWR net45 sky130_fd_sc_hd__buf_1
Xinput34 B[10] VGND VGND VPWR VPWR net34 sky130_fd_sc_hd__buf_1
X_1791_ net140 _0900_ _0901_ net129 VGND VGND VPWR VPWR _0902_ sky130_fd_sc_hd__o211a_1
Xinput67 alu_opcode[2] VGND VGND VPWR VPWR net67 sky130_fd_sc_hd__buf_6
X_1087_ net240 net239 net237 net236 net336 net212 VGND VGND VPWR VPWR _0220_ sky130_fd_sc_hd__mux4_1
X_1156_ net202 _0287_ _0285_ VGND VGND VPWR VPWR _0288_ sky130_fd_sc_hd__a21o_1
X_1225_ _0348_ _0321_ _0355_ VGND VGND VPWR VPWR net95 sky130_fd_sc_hd__or3b_4
XFILLER_16_29 VGND VGND VPWR VPWR sky130_fd_sc_hd__decap_4
XFILLER_32_39 VGND VGND VPWR VPWR sky130_fd_sc_hd__decap_4
X_1989_ net182 _0703_ _0860_ _0700_ VGND VGND VPWR VPWR _0078_ sky130_fd_sc_hd__a22oi_1
XFILLER_4_309 VGND VGND VPWR VPWR sky130_fd_sc_hd__decap_4
XFILLER_43_279 VGND VGND VPWR VPWR sky130_fd_sc_hd__fill_1
XFILLER_43_202 VGND VGND VPWR VPWR sky130_fd_sc_hd__decap_8
XFILLER_7_169 VPWR VGND VPWR VGND sky130_ef_sc_hd__decap_12
XFILLER_11_165 VGND VGND VPWR VPWR sky130_fd_sc_hd__decap_3
XFILLER_22_83 VGND VGND VPWR VPWR sky130_fd_sc_hd__fill_1
XFILLER_19_221 VGND VGND VPWR VPWR sky130_fd_sc_hd__decap_3
XFILLER_19_232 VGND VGND VPWR VPWR sky130_fd_sc_hd__fill_2
XFILLER_19_254 VPWR VGND VPWR VGND sky130_ef_sc_hd__decap_12
X_1843_ _0241_ _0856_ _0951_ net171 VGND VGND VPWR VPWR _0952_ sky130_fd_sc_hd__o22a_1
X_1912_ net241 net52 VGND VGND VPWR VPWR _0002_ sky130_fd_sc_hd__nor2_1
XFILLER_8_41 VGND VGND VPWR VPWR sky130_fd_sc_hd__decap_4
XFILLER_8_85 VGND VGND VPWR VPWR sky130_fd_sc_hd__fill_1
X_1774_ _0867_ _0862_ _0866_ VGND VGND VPWR VPWR _0885_ sky130_fd_sc_hd__a21o_1
XFILLER_6_180 VGND VGND VPWR VPWR sky130_fd_sc_hd__fill_2
XTAP_TAPCELL_ROW_12_182 VGND VPWR sky130_fd_sc_hd__tapvpwrvgnd_1
X_1208_ _0335_ net195 _0336_ _0240_ _0338_ VGND VGND VPWR VPWR _0339_ sky130_fd_sc_hd__a221o_1
XFILLER_27_39 VGND VGND VPWR VPWR sky130_fd_sc_hd__decap_4
XTAP_TAPCELL_ROW_4_139 VGND VPWR sky130_fd_sc_hd__tapvpwrvgnd_1
XFILLER_43_27 VPWR VGND VPWR VGND sky130_ef_sc_hd__decap_12
XFILLER_40_216 VGND VGND VPWR VPWR sky130_fd_sc_hd__decap_8
X_1139_ net211 net136 net131 net250 _0270_ VGND VGND VPWR VPWR _0271_ sky130_fd_sc_hd__a221o_1
XFILLER_25_279 VGND VGND VPWR VPWR sky130_fd_sc_hd__fill_1
XFILLER_48_305 VGND VGND VPWR VPWR sky130_fd_sc_hd__decap_3
XPHY_EDGE_ROW_9_Left_63 VGND VGND VPWR VPWR sky130_fd_sc_hd__decap_3
XFILLER_3_161 VGND VGND VPWR VPWR sky130_fd_sc_hd__decap_6
X_1490_ net152 _0611_ VGND VGND VPWR VPWR _0612_ sky130_fd_sc_hd__nand2_1
X_2042_ _0131_ _0134_ VGND VGND VPWR VPWR _0135_ sky130_fd_sc_hd__xnor2_1
XPHY_EDGE_ROW_8_Right_8 VGND VGND VPWR VPWR sky130_fd_sc_hd__decap_3
XFILLER_22_249 VGND VGND VPWR VPWR sky130_fd_sc_hd__decap_3
XFILLER_30_260 VPWR VGND VPWR VGND sky130_ef_sc_hd__decap_12
X_1826_ net49 net149 net144 _0934_ VGND VGND VPWR VPWR _0935_ sky130_fd_sc_hd__a211o_1
XPHY_EDGE_ROW_39_Right_39 VGND VGND VPWR VPWR sky130_fd_sc_hd__decap_3
X_1688_ _0802_ _0698_ net201 VGND VGND VPWR VPWR _0803_ sky130_fd_sc_hd__mux2_1
XFILLER_38_27 VGND VGND VPWR VPWR sky130_fd_sc_hd__fill_1
X_1757_ net46 net137 net132 net248 VGND VGND VPWR VPWR _0869_ sky130_fd_sc_hd__a22oi_1
XPHY_EDGE_ROW_48_Right_48 VGND VGND VPWR VPWR sky130_fd_sc_hd__decap_3
XPHY_EDGE_ROW_35_Left_89 VGND VGND VPWR VPWR sky130_fd_sc_hd__decap_3
XFILLER_13_216 VGND VGND VPWR VPWR sky130_fd_sc_hd__decap_8
XTAP_TAPCELL_ROW_23_244 VGND VPWR sky130_fd_sc_hd__tapvpwrvgnd_1
XFILLER_48_135 VGND VGND VPWR VPWR sky130_fd_sc_hd__decap_4
XFILLER_0_197 VGND VGND VPWR VPWR sky130_fd_sc_hd__fill_1
XTAP_TAPCELL_ROW_46_369 VGND VPWR sky130_fd_sc_hd__tapvpwrvgnd_1
X_1611_ net137 _0725_ VGND VGND VPWR VPWR _0729_ sky130_fd_sc_hd__nand2_1
XFILLER_8_253 VGND VGND VPWR VPWR sky130_fd_sc_hd__decap_8
XFILLER_12_293 VPWR VGND VPWR VGND sky130_ef_sc_hd__decap_12
X_1542_ net37 net147 VGND VGND VPWR VPWR _0662_ sky130_fd_sc_hd__nand2_1
X_1473_ net108 _0591_ _0593_ net109 VGND VGND VPWR VPWR _0596_ sky130_fd_sc_hd__o22ai_1
XFILLER_47_190 VPWR VGND VPWR VGND sky130_ef_sc_hd__decap_12
XFILLER_39_113 VGND VGND VPWR VPWR sky130_fd_sc_hd__decap_3
X_2025_ net88 _0932_ net87 VGND VGND VPWR VPWR _0116_ sky130_fd_sc_hd__mux2_1
XFILLER_24_29 VPWR VGND VPWR VGND sky130_ef_sc_hd__decap_12
X_1809_ _0918_ _0825_ net203 VGND VGND VPWR VPWR _0919_ sky130_fd_sc_hd__mux2_1
XTAP_TAPCELL_ROW_20_225 VGND VPWR sky130_fd_sc_hd__tapvpwrvgnd_1
XFILLER_49_15 VPWR VGND VPWR VGND sky130_ef_sc_hd__decap_12
XFILLER_53_182 VGND VGND VPWR VPWR sky130_fd_sc_hd__decap_6
XFILLER_45_105 VGND VGND VPWR VPWR sky130_fd_sc_hd__decap_6
XTAP_TAPCELL_ROW_51_394 VGND VPWR sky130_fd_sc_hd__tapvpwrvgnd_1
XFILLER_5_201 VGND VGND VPWR VPWR sky130_fd_sc_hd__fill_1
XFILLER_5_223 VGND VGND VPWR VPWR sky130_fd_sc_hd__fill_1
XFILLER_39_92 VGND VGND VPWR VPWR sky130_fd_sc_hd__fill_2
XFILLER_36_138 VGND VGND VPWR VPWR sky130_fd_sc_hd__fill_2
XFILLER_32_300 VGND VGND VPWR VPWR sky130_fd_sc_hd__decap_8
X_1387_ _0189_ _0509_ _0512_ _0226_ VGND VGND VPWR VPWR _0513_ sky130_fd_sc_hd__o211a_1
X_1456_ _0058_ _0569_ _0579_ _0563_ VGND VGND VPWR VPWR _0580_ sky130_fd_sc_hd__o211a_4
X_1525_ _0644_ _0645_ net115 VGND VGND VPWR VPWR _0646_ sky130_fd_sc_hd__a21o_1
XFILLER_42_108 VPWR VGND VPWR VGND sky130_ef_sc_hd__decap_12
X_2008_ _0296_ _0096_ _0097_ VGND VGND VPWR VPWR _0098_ sky130_fd_sc_hd__or3b_1
XFILLER_51_27 VPWR VGND VPWR VGND sky130_ef_sc_hd__decap_12
XFILLER_50_141 VPWR VGND VPWR VGND sky130_ef_sc_hd__decap_12
XFILLER_18_138 VGND VGND VPWR VPWR sky130_fd_sc_hd__fill_2
XFILLER_26_160 VGND VGND VPWR VPWR sky130_fd_sc_hd__fill_1
XPHY_EDGE_ROW_38_Left_92 VGND VGND VPWR VPWR sky130_fd_sc_hd__decap_3
X_1241_ net241 net21 net22 net237 net222 net212 VGND VGND VPWR VPWR _0371_ sky130_fd_sc_hd__mux4_1
XFILLER_1_281 VPWR VGND VPWR VGND sky130_ef_sc_hd__decap_12
X_1310_ _0153_ _0436_ _0437_ VGND VGND VPWR VPWR _0438_ sky130_fd_sc_hd__o21ai_1
XPHY_EDGE_ROW_22_Left_76 VGND VGND VPWR VPWR sky130_fd_sc_hd__decap_3
X_1172_ _0303_ _0302_ net200 VGND VGND VPWR VPWR _0304_ sky130_fd_sc_hd__mux2_1
XFILLER_2_65 VPWR VGND VPWR VGND sky130_ef_sc_hd__decap_12
XFILLER_24_119 VPWR VGND VPWR VGND sky130_ef_sc_hd__decap_12
XFILLER_32_141 VGND VGND VPWR VPWR sky130_fd_sc_hd__decap_8
Xoutput100 net100 VGND VGND VPWR VPWR Result[5] sky130_fd_sc_hd__buf_2
XFILLER_46_27 VGND VGND VPWR VPWR sky130_fd_sc_hd__fill_1
X_1508_ _0629_ _0510_ net200 VGND VGND VPWR VPWR _0630_ sky130_fd_sc_hd__mux2_1
X_1439_ _0561_ _0562_ net122 VGND VGND VPWR VPWR _0563_ sky130_fd_sc_hd__a21o_1
XTAP_TAPCELL_ROW_53_412 VGND VPWR sky130_fd_sc_hd__tapvpwrvgnd_1
XFILLER_23_152 VGND VGND VPWR VPWR sky130_fd_sc_hd__decap_6
XFILLER_2_3 VPWR VGND VPWR VGND sky130_ef_sc_hd__decap_12
Xinput13 A[20] VGND VGND VPWR VPWR net13 sky130_fd_sc_hd__clkbuf_1
X_1790_ net247 net47 VGND VGND VPWR VPWR _0901_ sky130_fd_sc_hd__nand2_1
XFILLER_14_141 VPWR VGND VPWR VGND sky130_ef_sc_hd__decap_12
Xinput24 A[30] VGND VGND VPWR VPWR net24 sky130_fd_sc_hd__buf_1
Xinput57 B[31] VGND VGND VPWR VPWR net57 sky130_fd_sc_hd__clkbuf_2
Xinput46 B[21] VGND VGND VPWR VPWR net46 sky130_fd_sc_hd__clkbuf_2
Xinput35 B[11] VGND VGND VPWR VPWR net35 sky130_fd_sc_hd__dlymetal6s2s_1
Xinput68 alu_opcode[3] VGND VGND VPWR VPWR net68 sky130_fd_sc_hd__buf_8
XFILLER_35_3 VPWR VGND VPWR VGND sky130_ef_sc_hd__decap_12
X_1224_ _0351_ _0353_ _0354_ net126 VGND VGND VPWR VPWR _0355_ sky130_fd_sc_hd__a31o_1
XFILLER_37_277 VGND VGND VPWR VPWR sky130_fd_sc_hd__decap_3
X_1086_ net224 net234 _0218_ VGND VGND VPWR VPWR _0219_ sky130_fd_sc_hd__a21oi_1
X_1155_ net234 _0286_ _0132_ VGND VGND VPWR VPWR _0287_ sky130_fd_sc_hd__mux2_1
XFILLER_32_29 VGND VGND VPWR VPWR sky130_fd_sc_hd__decap_6
X_1988_ _0073_ _0075_ _0076_ _0251_ VGND VGND VPWR VPWR _0077_ sky130_fd_sc_hd__a31o_1
XFILLER_28_266 VGND VGND VPWR VPWR sky130_fd_sc_hd__decap_4
XFILLER_11_111 VGND VGND VPWR VPWR sky130_fd_sc_hd__fill_1
XFILLER_11_133 VPWR VGND VPWR VGND sky130_ef_sc_hd__decap_12
XFILLER_3_321 VGND VGND VPWR VPWR sky130_fd_sc_hd__fill_1
XFILLER_11_199 VGND VGND VPWR VPWR sky130_fd_sc_hd__decap_3
Xfanout190 net191 VGND VGND VPWR VPWR net190 sky130_fd_sc_hd__buf_2
XFILLER_19_266 VGND VGND VPWR VPWR sky130_fd_sc_hd__fill_2
X_1842_ _0894_ _0950_ net178 VGND VGND VPWR VPWR _0951_ sky130_fd_sc_hd__mux2_1
X_1773_ net170 _0884_ VGND VGND VPWR VPWR net86 sky130_fd_sc_hd__nor2_4
XFILLER_8_75 VGND VGND VPWR VPWR sky130_fd_sc_hd__decap_4
XTAP_TAPCELL_ROW_12_183 VGND VPWR sky130_fd_sc_hd__tapvpwrvgnd_1
X_1911_ _0177_ _0260_ net52 VGND VGND VPWR VPWR _0001_ sky130_fd_sc_hd__or3b_1
X_1207_ net180 _0242_ _0337_ _0237_ VGND VGND VPWR VPWR _0338_ sky130_fd_sc_hd__o211a_1
XFILLER_43_39 VPWR VGND VPWR VGND sky130_ef_sc_hd__decap_12
X_1138_ _0264_ _0269_ VGND VGND VPWR VPWR _0270_ sky130_fd_sc_hd__xnor2_1
XFILLER_25_225 VGND VGND VPWR VPWR sky130_fd_sc_hd__decap_4
X_1069_ _0198_ _0201_ _0193_ VGND VGND VPWR VPWR _0202_ sky130_fd_sc_hd__a21o_1
XFILLER_0_313 VGND VGND VPWR VPWR sky130_fd_sc_hd__decap_4
XFILLER_0_302 VGND VGND VPWR VPWR sky130_fd_sc_hd__decap_6
XFILLER_16_225 VGND VGND VPWR VPWR sky130_fd_sc_hd__decap_4
XFILLER_16_258 VGND VGND VPWR VPWR sky130_fd_sc_hd__decap_8
XFILLER_17_51 VGND VGND VPWR VPWR sky130_fd_sc_hd__decap_4
X_2041_ _0432_ net333 _0133_ VGND VGND VPWR VPWR _0134_ sky130_fd_sc_hd__o21a_1
XFILLER_22_206 VGND VGND VPWR VPWR sky130_fd_sc_hd__fill_2
XTAP_TAPCELL_ROW_32_289 VGND VPWR sky130_fd_sc_hd__tapvpwrvgnd_1
XFILLER_30_272 VPWR VGND VPWR VGND sky130_ef_sc_hd__decap_12
X_1756_ _0867_ net281 VGND VGND VPWR VPWR _0868_ sky130_fd_sc_hd__xnor2_1
X_1825_ net49 net163 VGND VGND VPWR VPWR _0934_ sky130_fd_sc_hd__nor2_1
X_1687_ _0759_ _0801_ net178 VGND VGND VPWR VPWR _0802_ sky130_fd_sc_hd__mux2_1
XTAP_TAPCELL_ROW_0_110 VGND VPWR sky130_fd_sc_hd__tapvpwrvgnd_1
XFILLER_36_309 VGND VGND VPWR VPWR sky130_fd_sc_hd__decap_4
X_1610_ net140 _0724_ _0725_ net119 net183 VGND VGND VPWR VPWR _0728_ sky130_fd_sc_hd__o32a_1
XFILLER_8_265 VGND VGND VPWR VPWR sky130_fd_sc_hd__decap_4
XFILLER_8_276 VPWR VGND VPWR VGND sky130_ef_sc_hd__decap_12
XFILLER_39_103 VGND VGND VPWR VPWR sky130_fd_sc_hd__decap_3
X_1541_ _0640_ _0635_ _0639_ VGND VGND VPWR VPWR _0661_ sky130_fd_sc_hd__a21o_1
X_1472_ _0593_ _0594_ VGND VGND VPWR VPWR _0595_ sky130_fd_sc_hd__and2_1
X_2024_ net87 net88 VGND VGND VPWR VPWR _0115_ sky130_fd_sc_hd__nor2_1
XFILLER_39_169 VGND VGND VPWR VPWR sky130_fd_sc_hd__decap_6
XFILLER_35_320 VGND VGND VPWR VPWR sky130_fd_sc_hd__fill_2
XTAP_TAPCELL_ROW_20_226 VGND VPWR sky130_fd_sc_hd__tapvpwrvgnd_1
XFILLER_49_27 VPWR VGND VPWR VGND sky130_ef_sc_hd__decap_12
X_1808_ _0871_ _0917_ net179 VGND VGND VPWR VPWR _0918_ sky130_fd_sc_hd__mux2_1
XFILLER_40_29 VPWR VGND VPWR VGND sky130_ef_sc_hd__decap_12
X_1739_ _0847_ _0851_ VGND VGND VPWR VPWR _0852_ sky130_fd_sc_hd__nand2_1
XFILLER_26_320 VGND VGND VPWR VPWR sky130_fd_sc_hd__fill_2
XTAP_TAPCELL_ROW_51_395 VGND VPWR sky130_fd_sc_hd__tapvpwrvgnd_1
XFILLER_30_40 VPWR VGND VPWR VGND sky130_ef_sc_hd__decap_12
XFILLER_14_41 VPWR VGND VPWR VGND sky130_ef_sc_hd__decap_12
XFILLER_14_85 VGND VGND VPWR VPWR sky130_fd_sc_hd__decap_6
XFILLER_14_96 VGND VGND VPWR VPWR sky130_fd_sc_hd__decap_6
XFILLER_5_279 VGND VGND VPWR VPWR sky130_fd_sc_hd__fill_1
X_1524_ net215 net36 VGND VGND VPWR VPWR _0645_ sky130_fd_sc_hd__or2_1
X_1386_ _0344_ _0511_ VGND VGND VPWR VPWR _0512_ sky130_fd_sc_hd__nand2_1
X_1455_ _0248_ _0578_ VGND VGND VPWR VPWR _0579_ sky130_fd_sc_hd__nand2_1
X_2007_ net175 _0919_ _0008_ _0241_ VGND VGND VPWR VPWR _0097_ sky130_fd_sc_hd__o22a_1
XFILLER_35_150 VPWR VGND VPWR VGND sky130_ef_sc_hd__decap_12
XFILLER_51_39 VPWR VGND VPWR VGND sky130_ef_sc_hd__decap_12
XFILLER_50_197 VGND VGND VPWR VPWR sky130_fd_sc_hd__fill_2
XFILLER_33_109 VGND VGND VPWR VPWR sky130_fd_sc_hd__decap_3
XFILLER_18_106 VGND VGND VPWR VPWR sky130_fd_sc_hd__fill_1
XFILLER_41_131 VGND VGND VPWR VPWR sky130_fd_sc_hd__decap_4
XFILLER_14_301 VGND VGND VPWR VPWR sky130_fd_sc_hd__decap_6
X_1171_ net250 net238 net26 net232 net218 net209 VGND VGND VPWR VPWR _0303_ sky130_fd_sc_hd__mux4_1
X_1240_ net202 _0368_ VGND VGND VPWR VPWR _0370_ sky130_fd_sc_hd__nand2_1
XFILLER_2_77 VGND VGND VPWR VPWR sky130_fd_sc_hd__decap_6
XFILLER_1_293 VPWR VGND VPWR VGND sky130_ef_sc_hd__decap_12
XFILLER_17_183 VGND VGND VPWR VPWR sky130_fd_sc_hd__fill_1
XFILLER_20_315 VGND VGND VPWR VPWR sky130_fd_sc_hd__fill_1
X_1507_ _0573_ _0628_ net180 VGND VGND VPWR VPWR _0629_ sky130_fd_sc_hd__mux2_1
Xoutput101 net101 VGND VGND VPWR VPWR Result[6] sky130_fd_sc_hd__buf_2
X_1438_ net64 net135 net127 _0162_ VGND VGND VPWR VPWR _0562_ sky130_fd_sc_hd__o2bb2a_1
X_1369_ _0491_ _0493_ _0495_ net126 VGND VGND VPWR VPWR _0496_ sky130_fd_sc_hd__a31o_1
XTAP_TAPCELL_ROW_53_413 VGND VPWR sky130_fd_sc_hd__tapvpwrvgnd_1
XFILLER_36_83 VGND VGND VPWR VPWR sky130_fd_sc_hd__fill_1
XFILLER_36_61 VGND VGND VPWR VPWR sky130_fd_sc_hd__fill_1
XFILLER_14_120 VGND VGND VPWR VPWR sky130_fd_sc_hd__decap_4
Xinput25 A[31] VGND VGND VPWR VPWR net25 sky130_fd_sc_hd__clkbuf_1
Xinput14 A[21] VGND VGND VPWR VPWR net14 sky130_fd_sc_hd__buf_1
Xinput36 B[12] VGND VGND VPWR VPWR net36 sky130_fd_sc_hd__dlymetal6s2s_1
XFILLER_14_153 VPWR VGND VPWR VGND sky130_ef_sc_hd__decap_12
XFILLER_14_197 VGND VGND VPWR VPWR sky130_fd_sc_hd__decap_4
Xinput47 B[22] VGND VGND VPWR VPWR net47 sky130_fd_sc_hd__dlymetal6s2s_1
Xinput58 B[3] VGND VGND VPWR VPWR net58 sky130_fd_sc_hd__buf_1
Xinput69 alu_opcode[4] VGND VGND VPWR VPWR net69 sky130_fd_sc_hd__buf_4
XFILLER_37_256 VGND VGND VPWR VPWR sky130_fd_sc_hd__fill_1
XFILLER_37_223 VGND VGND VPWR VPWR sky130_fd_sc_hd__fill_1
XFILLER_37_212 VGND VGND VPWR VPWR sky130_fd_sc_hd__fill_1
X_1154_ net239 net237 net224 VGND VGND VPWR VPWR _0286_ sky130_fd_sc_hd__mux2_1
XFILLER_28_3 VPWR VGND VPWR VGND sky130_ef_sc_hd__decap_12
X_1223_ net161 net134 _0349_ VGND VGND VPWR VPWR _0354_ sky130_fd_sc_hd__mux2_1
XFILLER_52_248 VGND VGND VPWR VPWR sky130_fd_sc_hd__decap_4
X_1085_ _0110_ net237 VGND VGND VPWR VPWR _0218_ sky130_fd_sc_hd__and2_1
X_1987_ net134 net164 _0072_ VGND VGND VPWR VPWR _0076_ sky130_fd_sc_hd__mux2_1
XFILLER_51_281 VPWR VGND VPWR VGND sky130_ef_sc_hd__decap_12
XFILLER_11_145 VPWR VGND VPWR VGND sky130_ef_sc_hd__decap_12
XFILLER_7_149 VPWR VGND VPWR VGND sky130_ef_sc_hd__decap_12
XFILLER_22_85 VGND VGND VPWR VPWR sky130_fd_sc_hd__decap_4
Xfanout180 _0132_ VGND VGND VPWR VPWR net180 sky130_fd_sc_hd__buf_6
Xfanout191 net192 VGND VGND VPWR VPWR net191 sky130_fd_sc_hd__clkbuf_4
XTAP_TAPCELL_ROW_29_273 VGND VPWR sky130_fd_sc_hd__tapvpwrvgnd_1
X_1910_ _1014_ _1015_ VGND VGND VPWR VPWR _0000_ sky130_fd_sc_hd__nand2_1
X_1841_ net17 net16 net223 VGND VGND VPWR VPWR _0950_ sky130_fd_sc_hd__mux2_1
X_1772_ _0068_ _0877_ _0883_ net126 _0870_ VGND VGND VPWR VPWR _0884_ sky130_fd_sc_hd__o221a_4
XFILLER_6_160 VGND VGND VPWR VPWR sky130_fd_sc_hd__decap_4
XTAP_TAPCELL_ROW_12_184 VGND VPWR sky130_fd_sc_hd__tapvpwrvgnd_1
X_1206_ net209 _0236_ VGND VGND VPWR VPWR _0337_ sky130_fd_sc_hd__or2_1
X_1137_ _0100_ _0267_ _0268_ VGND VGND VPWR VPWR _0269_ sky130_fd_sc_hd__o21ai_1
XFILLER_25_204 VGND VGND VPWR VPWR sky130_fd_sc_hd__decap_8
XFILLER_33_281 VGND VGND VPWR VPWR sky130_fd_sc_hd__fill_1
X_1068_ net216 _0178_ net187 _0184_ VGND VGND VPWR VPWR _0201_ sky130_fd_sc_hd__a211o_1
XTAP_TAPCELL_ROW_3_130 VGND VPWR sky130_fd_sc_hd__tapvpwrvgnd_1
XFILLER_31_207 VGND VGND VPWR VPWR sky130_fd_sc_hd__fill_2
XFILLER_16_237 VGND VGND VPWR VPWR sky130_fd_sc_hd__decap_4
XFILLER_33_73 VPWR VGND VPWR VGND sky130_ef_sc_hd__decap_12
XFILLER_33_51 VGND VGND VPWR VPWR sky130_fd_sc_hd__decap_4
XFILLER_3_141 VGND VGND VPWR VPWR sky130_fd_sc_hd__fill_1
X_2040_ net99 net100 VGND VGND VPWR VPWR _0133_ sky130_fd_sc_hd__or2_1
XTAP_TAPCELL_ROW_17_210 VGND VPWR sky130_fd_sc_hd__tapvpwrvgnd_1
XFILLER_15_281 VGND VGND VPWR VPWR sky130_fd_sc_hd__fill_1
X_1686_ net10 net9 net220 VGND VGND VPWR VPWR _0801_ sky130_fd_sc_hd__mux2_1
XFILLER_30_284 VGND VGND VPWR VPWR sky130_fd_sc_hd__fill_2
X_1755_ _0865_ _0866_ VGND VGND VPWR VPWR _0867_ sky130_fd_sc_hd__nor2_1
X_1824_ _0174_ _0910_ _0911_ _0907_ VGND VGND VPWR VPWR _0933_ sky130_fd_sc_hd__a2bb2o_4
XFILLER_38_29 VPWR VGND VPWR VGND sky130_ef_sc_hd__decap_12
XFILLER_53_321 VGND VGND VPWR VPWR sky130_fd_sc_hd__fill_1
XTAP_TAPCELL_ROW_0_111 VGND VPWR sky130_fd_sc_hd__tapvpwrvgnd_1
XFILLER_21_240 VGND VGND VPWR VPWR sky130_fd_sc_hd__fill_1
XFILLER_0_111 VGND VGND VPWR VPWR sky130_fd_sc_hd__fill_1
XFILLER_0_144 VGND VGND VPWR VPWR sky130_fd_sc_hd__decap_4
XFILLER_44_321 VGND VGND VPWR VPWR sky130_fd_sc_hd__fill_1
XFILLER_44_94 VGND VGND VPWR VPWR sky130_fd_sc_hd__decap_3
XFILLER_5_55 VGND VGND VPWR VPWR sky130_fd_sc_hd__fill_1
XFILLER_8_233 VPWR VGND VPWR VGND sky130_ef_sc_hd__decap_12
XFILLER_8_288 VGND VGND VPWR VPWR sky130_fd_sc_hd__decap_8
XFILLER_12_273 VGND VGND VPWR VPWR sky130_fd_sc_hd__fill_1
X_1540_ _0660_ VGND VGND VPWR VPWR net76 sky130_fd_sc_hd__inv_2
XFILLER_5_77 VGND VGND VPWR VPWR sky130_fd_sc_hd__decap_8
XFILLER_10_3 VPWR VGND VPWR VGND sky130_ef_sc_hd__decap_12
X_1471_ net143 _0591_ net166 VGND VGND VPWR VPWR _0594_ sky130_fd_sc_hd__a21o_1
X_2023_ net89 _0981_ _0113_ VGND VGND VPWR VPWR _0114_ sky130_fd_sc_hd__a21bo_1
X_1807_ net246 net15 net222 VGND VGND VPWR VPWR _0917_ sky130_fd_sc_hd__mux2_1
XTAP_TAPCELL_ROW_20_227 VGND VPWR sky130_fd_sc_hd__tapvpwrvgnd_1
XFILLER_49_39 VPWR VGND VPWR VGND sky130_ef_sc_hd__decap_12
X_1669_ _0237_ _0298_ net112 net107 VGND VGND VPWR VPWR _0785_ sky130_fd_sc_hd__a31o_1
X_1738_ net144 _0848_ net132 VGND VGND VPWR VPWR _0851_ sky130_fd_sc_hd__a21o_1
XFILLER_45_129 VGND VGND VPWR VPWR sky130_fd_sc_hd__decap_8
XFILLER_53_151 VGND VGND VPWR VPWR sky130_fd_sc_hd__decap_6
XFILLER_14_53 VPWR VGND VPWR VGND sky130_ef_sc_hd__decap_12
XTAP_TAPCELL_ROW_51_396 VGND VPWR sky130_fd_sc_hd__tapvpwrvgnd_1
XFILLER_30_74 VGND VGND VPWR VPWR sky130_fd_sc_hd__decap_8
XFILLER_30_52 VGND VGND VPWR VPWR sky130_fd_sc_hd__decap_8
XFILLER_36_129 VGND VGND VPWR VPWR sky130_fd_sc_hd__fill_1
XFILLER_29_181 VGND VGND VPWR VPWR sky130_fd_sc_hd__decap_8
X_1523_ net215 net36 VGND VGND VPWR VPWR _0644_ sky130_fd_sc_hd__nand2_1
X_1454_ net190 _0571_ _0577_ VGND VGND VPWR VPWR _0578_ sky130_fd_sc_hd__a21o_1
X_1385_ _0510_ _0388_ net198 VGND VGND VPWR VPWR _0511_ sky130_fd_sc_hd__mux2_1
XFILLER_50_121 VPWR VGND VPWR VGND sky130_ef_sc_hd__decap_12
X_2006_ _0237_ _0290_ _0373_ _0095_ VGND VGND VPWR VPWR _0096_ sky130_fd_sc_hd__and4_1
XFILLER_35_162 VGND VGND VPWR VPWR sky130_fd_sc_hd__fill_2
Xrebuffer81 _0465_ VGND VGND VPWR VPWR net333 sky130_fd_sc_hd__dlygate4sd1_1
XFILLER_41_51 VGND VGND VPWR VPWR sky130_fd_sc_hd__decap_4
X_1170_ net231 net230 net228 net227 net218 net209 VGND VGND VPWR VPWR _0302_ sky130_fd_sc_hd__mux4_1
X_1506_ net3 net2 net217 VGND VGND VPWR VPWR _0628_ sky130_fd_sc_hd__mux2_1
X_1437_ _0554_ _0560_ VGND VGND VPWR VPWR _0561_ sky130_fd_sc_hd__xnor2_1
Xoutput102 net102 VGND VGND VPWR VPWR Result[7] sky130_fd_sc_hd__buf_2
XTAP_TAPCELL_ROW_53_414 VGND VPWR sky130_fd_sc_hd__tapvpwrvgnd_1
XFILLER_46_29 VPWR VGND VPWR VGND sky130_ef_sc_hd__decap_12
X_1368_ net134 _0489_ _0492_ _0494_ VGND VGND VPWR VPWR _0495_ sky130_fd_sc_hd__o211a_1
X_1299_ _0143_ _0187_ _0425_ net166 VGND VGND VPWR VPWR _0428_ sky130_fd_sc_hd__a22o_1
Xinput15 A[22] VGND VGND VPWR VPWR net15 sky130_fd_sc_hd__buf_1
XFILLER_52_61 VGND VGND VPWR VPWR sky130_fd_sc_hd__fill_2
Xinput26 A[3] VGND VGND VPWR VPWR net26 sky130_fd_sc_hd__buf_1
Xinput48 B[23] VGND VGND VPWR VPWR net48 sky130_fd_sc_hd__clkbuf_2
Xinput59 B[4] VGND VGND VPWR VPWR net59 sky130_fd_sc_hd__buf_1
Xinput37 B[13] VGND VGND VPWR VPWR net37 sky130_fd_sc_hd__buf_1
XFILLER_14_165 VGND VGND VPWR VPWR sky130_fd_sc_hd__decap_6
X_1084_ net245 net244 net243 net241 net221 net212 VGND VGND VPWR VPWR _0217_ sky130_fd_sc_hd__mux4_1
X_1153_ net203 _0284_ VGND VGND VPWR VPWR _0285_ sky130_fd_sc_hd__and2b_1
X_1222_ net238 net198 _0352_ VGND VGND VPWR VPWR _0353_ sky130_fd_sc_hd__a21o_1
X_1986_ net133 _0074_ _0071_ VGND VGND VPWR VPWR _0075_ sky130_fd_sc_hd__o21ai_1
XFILLER_20_135 VGND VGND VPWR VPWR sky130_fd_sc_hd__fill_2
XFILLER_51_293 VPWR VGND VPWR VGND sky130_ef_sc_hd__decap_12
XFILLER_11_113 VPWR VGND VPWR VGND sky130_ef_sc_hd__decap_12
XFILLER_11_157 VGND VGND VPWR VPWR sky130_fd_sc_hd__decap_8
Xfanout192 net59 VGND VGND VPWR VPWR net192 sky130_fd_sc_hd__buf_2
XTAP_TAPCELL_ROW_6_150 VGND VPWR sky130_fd_sc_hd__tapvpwrvgnd_1
XFILLER_19_279 VGND VGND VPWR VPWR sky130_fd_sc_hd__fill_1
Xfanout170 _0182_ VGND VGND VPWR VPWR net170 sky130_fd_sc_hd__buf_4
Xfanout181 _0079_ VGND VGND VPWR VPWR net181 sky130_fd_sc_hd__buf_2
X_1840_ net195 _0368_ _0547_ net111 net107 VGND VGND VPWR VPWR _0949_ sky130_fd_sc_hd__a221o_1
XTAP_TAPCELL_ROW_29_274 VGND VPWR sky130_fd_sc_hd__tapvpwrvgnd_1
X_1771_ net248 net46 net109 _0879_ _0882_ VGND VGND VPWR VPWR _0883_ sky130_fd_sc_hd__o311a_1
XFILLER_40_3 VPWR VGND VPWR VGND sky130_ef_sc_hd__decap_12
X_1205_ net230 net228 net227 net225 net218 net209 VGND VGND VPWR VPWR _0336_ sky130_fd_sc_hd__mux4_1
X_1136_ _0266_ net250 net153 VGND VGND VPWR VPWR _0268_ sky130_fd_sc_hd__o21a_1
X_1067_ _0178_ net272 _0184_ VGND VGND VPWR VPWR _0200_ sky130_fd_sc_hd__or3_1
X_1969_ _0238_ _0055_ _0056_ VGND VGND VPWR VPWR _0057_ sky130_fd_sc_hd__o21a_1
XTAP_TAPCELL_ROW_3_131 VGND VPWR sky130_fd_sc_hd__tapvpwrvgnd_1
XFILLER_16_249 VGND VGND VPWR VPWR sky130_fd_sc_hd__decap_3
XFILLER_17_86 VGND VGND VPWR VPWR sky130_fd_sc_hd__fill_2
XFILLER_33_85 VPWR VGND VPWR VGND sky130_ef_sc_hd__decap_12
XTAP_TAPCELL_ROW_17_211 VGND VPWR sky130_fd_sc_hd__tapvpwrvgnd_1
X_1823_ net169 _0932_ VGND VGND VPWR VPWR net88 sky130_fd_sc_hd__nor2_4
XFILLER_30_296 VGND VGND VPWR VPWR sky130_fd_sc_hd__decap_3
X_1754_ net248 net155 _0864_ VGND VGND VPWR VPWR _0866_ sky130_fd_sc_hd__and3_1
X_1685_ net42 net137 net132 net252 _0799_ VGND VGND VPWR VPWR _0800_ sky130_fd_sc_hd__a221o_1
XTAP_TAPCELL_ROW_48_380 VGND VPWR sky130_fd_sc_hd__tapvpwrvgnd_1
X_1119_ net1 net216 VGND VGND VPWR VPWR _0252_ sky130_fd_sc_hd__nand2_1
XTAP_TAPCELL_ROW_0_112 VGND VPWR sky130_fd_sc_hd__tapvpwrvgnd_1
XPHY_EDGE_ROW_17_Right_17 VGND VGND VPWR VPWR sky130_fd_sc_hd__decap_3
XPHY_EDGE_ROW_26_Right_26 VGND VGND VPWR VPWR sky130_fd_sc_hd__decap_3
XFILLER_0_167 VGND VGND VPWR VPWR sky130_fd_sc_hd__fill_1
XPHY_EDGE_ROW_35_Right_35 VGND VGND VPWR VPWR sky130_fd_sc_hd__decap_3
XFILLER_8_245 VGND VGND VPWR VPWR sky130_fd_sc_hd__decap_6
XFILLER_5_89 VPWR VGND VPWR VGND sky130_ef_sc_hd__decap_12
X_1470_ net242 net34 VGND VGND VPWR VPWR _0593_ sky130_fd_sc_hd__or2_1
XPHY_EDGE_ROW_44_Right_44 VGND VGND VPWR VPWR sky130_fd_sc_hd__decap_3
XPHY_EDGE_ROW_53_Right_53 VGND VGND VPWR VPWR sky130_fd_sc_hd__decap_3
XTAP_TAPCELL_ROW_45_361 VGND VPWR sky130_fd_sc_hd__tapvpwrvgnd_1
X_2022_ _0956_ _0982_ VGND VGND VPWR VPWR _0113_ sky130_fd_sc_hd__nand2_1
XTAP_TAPCELL_ROW_37_317 VGND VPWR sky130_fd_sc_hd__tapvpwrvgnd_1
X_1806_ net191 _0517_ _0860_ _0512_ VGND VGND VPWR VPWR _0916_ sky130_fd_sc_hd__a2bb2o_1
XTAP_TAPCELL_ROW_20_228 VGND VPWR sky130_fd_sc_hd__tapvpwrvgnd_1
X_1599_ net39 net149 net144 _0716_ VGND VGND VPWR VPWR _0717_ sky130_fd_sc_hd__a211o_1
X_1737_ _0207_ net162 _0848_ VGND VGND VPWR VPWR _0850_ sky130_fd_sc_hd__mux2_1
X_1668_ _0207_ net165 _0782_ VGND VGND VPWR VPWR _0784_ sky130_fd_sc_hd__mux2_1
XFILLER_26_300 VGND VGND VPWR VPWR sky130_fd_sc_hd__decap_8
XTAP_TAPCELL_ROW_51_397 VGND VPWR sky130_fd_sc_hd__tapvpwrvgnd_1
XPHY_EDGE_ROW_46_Left_100 VGND VGND VPWR VPWR sky130_fd_sc_hd__decap_3
XFILLER_14_65 VGND VGND VPWR VPWR sky130_fd_sc_hd__decap_4
XFILLER_39_51 VGND VGND VPWR VPWR sky130_fd_sc_hd__decap_4
X_1453_ net111 _0572_ _0576_ _0295_ VGND VGND VPWR VPWR _0577_ sky130_fd_sc_hd__a22o_1
X_1522_ _0642_ _0641_ net122 VGND VGND VPWR VPWR _0643_ sky130_fd_sc_hd__a21o_1
X_2005_ net212 _0054_ VGND VGND VPWR VPWR _0095_ sky130_fd_sc_hd__nand2_1
X_1384_ net228 net29 net28 net27 net217 net208 VGND VGND VPWR VPWR _0510_ sky130_fd_sc_hd__mux4_1
XFILLER_50_133 VGND VGND VPWR VPWR sky130_fd_sc_hd__decap_6
XFILLER_50_100 VGND VGND VPWR VPWR sky130_fd_sc_hd__fill_1
XFILLER_35_141 VGND VGND VPWR VPWR sky130_fd_sc_hd__fill_1
XFILLER_41_111 VGND VGND VPWR VPWR sky130_fd_sc_hd__fill_1
XFILLER_26_141 VPWR VGND VPWR VGND sky130_ef_sc_hd__decap_12
Xrebuffer82 net95 VGND VGND VPWR VPWR net334 sky130_fd_sc_hd__dlymetal6s2s_1
XFILLER_41_144 VPWR VGND VPWR VGND sky130_ef_sc_hd__decap_12
XFILLER_49_222 VGND VGND VPWR VPWR sky130_fd_sc_hd__fill_2
XFILLER_32_122 VGND VGND VPWR VPWR sky130_fd_sc_hd__fill_1
Xoutput103 net103 VGND VGND VPWR VPWR Result[8] sky130_fd_sc_hd__clkbuf_4
X_1505_ _0380_ _0384_ net175 VGND VGND VPWR VPWR _0627_ sky130_fd_sc_hd__mux2_1
X_1436_ _0557_ _0559_ VGND VGND VPWR VPWR _0560_ sky130_fd_sc_hd__and2_1
X_1367_ net230 net118 _0488_ net159 VGND VGND VPWR VPWR _0494_ sky130_fd_sc_hd__o22a_1
XTAP_TAPCELL_ROW_53_415 VGND VPWR sky130_fd_sc_hd__tapvpwrvgnd_1
X_1298_ net190 net232 _0261_ _0426_ VGND VGND VPWR VPWR _0427_ sky130_fd_sc_hd__a31o_1
XFILLER_11_55 VGND VGND VPWR VPWR sky130_fd_sc_hd__fill_1
XFILLER_36_85 VGND VGND VPWR VPWR sky130_fd_sc_hd__fill_1
XFILLER_36_41 VPWR VGND VPWR VGND sky130_ef_sc_hd__decap_12
XFILLER_14_133 VGND VGND VPWR VPWR sky130_fd_sc_hd__decap_6
Xinput16 A[23] VGND VGND VPWR VPWR net16 sky130_fd_sc_hd__clkbuf_1
Xinput27 A[4] VGND VGND VPWR VPWR net27 sky130_fd_sc_hd__buf_1
Xinput49 B[24] VGND VGND VPWR VPWR net49 sky130_fd_sc_hd__clkbuf_2
Xinput38 B[14] VGND VGND VPWR VPWR net38 sky130_fd_sc_hd__clkbuf_2
X_1221_ net238 net121 net141 _0349_ net128 VGND VGND VPWR VPWR _0352_ sky130_fd_sc_hd__o221a_1
X_1152_ net244 net243 net241 net240 net221 net212 VGND VGND VPWR VPWR _0284_ sky130_fd_sc_hd__mux4_1
X_1083_ _0213_ _0215_ net205 VGND VGND VPWR VPWR _0216_ sky130_fd_sc_hd__mux2_1
XFILLER_37_269 VGND VGND VPWR VPWR sky130_fd_sc_hd__decap_8
X_1985_ net237 net120 net145 _0072_ VGND VGND VPWR VPWR _0074_ sky130_fd_sc_hd__a2bb2o_1
X_1419_ _0543_ _0419_ net200 VGND VGND VPWR VPWR _0544_ sky130_fd_sc_hd__mux2_1
XFILLER_28_203 VGND VGND VPWR VPWR sky130_fd_sc_hd__fill_1
XFILLER_36_291 VGND VGND VPWR VPWR sky130_fd_sc_hd__decap_4
XTAP_TAPCELL_ROW_6_151 VGND VPWR sky130_fd_sc_hd__tapvpwrvgnd_1
XFILLER_47_51 VGND VGND VPWR VPWR sky130_fd_sc_hd__decap_4
Xfanout171 _0238_ VGND VGND VPWR VPWR net171 sky130_fd_sc_hd__clkbuf_4
Xfanout182 _0079_ VGND VGND VPWR VPWR net182 sky130_fd_sc_hd__buf_2
XTAP_TAPCELL_ROW_29_275 VGND VPWR sky130_fd_sc_hd__tapvpwrvgnd_1
Xfanout160 net161 VGND VGND VPWR VPWR net160 sky130_fd_sc_hd__clkbuf_2
Xfanout193 net197 VGND VGND VPWR VPWR net193 sky130_fd_sc_hd__buf_2
X_1770_ net248 net46 net108 _0881_ VGND VGND VPWR VPWR _0882_ sky130_fd_sc_hd__a31o_1
XFILLER_8_45 VGND VGND VPWR VPWR sky130_fd_sc_hd__fill_1
XFILLER_8_89 VPWR VGND VPWR VGND sky130_ef_sc_hd__decap_12
X_1204_ _0333_ _0334_ net201 VGND VGND VPWR VPWR _0335_ sky130_fd_sc_hd__mux2_2
XFILLER_33_3 VPWR VGND VPWR VGND sky130_ef_sc_hd__decap_12
X_1135_ net153 _0266_ VGND VGND VPWR VPWR _0267_ sky130_fd_sc_hd__nand2_1
X_1066_ _0178_ net187 _0184_ VGND VGND VPWR VPWR _0199_ sky130_fd_sc_hd__nor3_1
X_1968_ net175 _0873_ _0976_ _0241_ net114 VGND VGND VPWR VPWR _0056_ sky130_fd_sc_hd__o221a_1
X_1899_ _1004_ _1005_ net184 VGND VGND VPWR VPWR _1006_ sky130_fd_sc_hd__o21a_1
XFILLER_48_309 VGND VGND VPWR VPWR sky130_fd_sc_hd__decap_4
XTAP_TAPCELL_ROW_3_132 VGND VPWR sky130_fd_sc_hd__tapvpwrvgnd_1
XFILLER_17_43 VGND VGND VPWR VPWR sky130_fd_sc_hd__fill_1
XTAP_TAPCELL_ROW_26_256 VGND VPWR sky130_fd_sc_hd__tapvpwrvgnd_1
XFILLER_24_250 VGND VGND VPWR VPWR sky130_fd_sc_hd__fill_2
XFILLER_24_261 VGND VGND VPWR VPWR sky130_fd_sc_hd__decap_8
XFILLER_33_97 VPWR VGND VPWR VGND sky130_ef_sc_hd__decap_12
X_1822_ _0922_ _0931_ _0915_ VGND VGND VPWR VPWR _0932_ sky130_fd_sc_hd__o21a_1
XFILLER_30_220 VGND VGND VPWR VPWR sky130_fd_sc_hd__decap_6
XPHY_EDGE_ROW_29_Left_83 VGND VGND VPWR VPWR sky130_fd_sc_hd__decap_3
X_1753_ net248 _0864_ net155 VGND VGND VPWR VPWR _0865_ sky130_fd_sc_hd__o21ai_1
X_1684_ _0798_ net260 VGND VGND VPWR VPWR _0799_ sky130_fd_sc_hd__xnor2_1
XFILLER_53_312 VGND VGND VPWR VPWR sky130_fd_sc_hd__decap_6
XFILLER_53_301 VGND VGND VPWR VPWR sky130_fd_sc_hd__decap_6
XTAP_TAPCELL_ROW_0_113 VGND VPWR sky130_fd_sc_hd__tapvpwrvgnd_1
XPHY_EDGE_ROW_13_Left_67 VGND VGND VPWR VPWR sky130_fd_sc_hd__decap_3
XTAP_TAPCELL_ROW_48_381 VGND VPWR sky130_fd_sc_hd__tapvpwrvgnd_1
X_1049_ _0058_ _0068_ VGND VGND VPWR VPWR _0182_ sky130_fd_sc_hd__nor2_1
X_1118_ net68 _0068_ VGND VGND VPWR VPWR _0251_ sky130_fd_sc_hd__nand2_1
XFILLER_48_139 VGND VGND VPWR VPWR sky130_fd_sc_hd__fill_1
XFILLER_0_113 VGND VGND VPWR VPWR sky130_fd_sc_hd__decap_4
XFILLER_44_41 VPWR VGND VPWR VGND sky130_ef_sc_hd__decap_12
XFILLER_28_97 VGND VGND VPWR VPWR sky130_fd_sc_hd__decap_3
XFILLER_28_42 VGND VGND VPWR VPWR sky130_fd_sc_hd__decap_3
XFILLER_12_231 VGND VGND VPWR VPWR sky130_fd_sc_hd__fill_1
XFILLER_12_253 VGND VGND VPWR VPWR sky130_fd_sc_hd__fill_1
X_2021_ net92 _0014_ net91 VGND VGND VPWR VPWR _0112_ sky130_fd_sc_hd__mux2_1
XTAP_TAPCELL_ROW_37_318 VGND VPWR sky130_fd_sc_hd__tapvpwrvgnd_1
XTAP_TAPCELL_ROW_45_362 VGND VPWR sky130_fd_sc_hd__tapvpwrvgnd_1
X_1736_ net116 _0839_ _0847_ _0848_ VGND VGND VPWR VPWR _0849_ sky130_fd_sc_hd__a22o_1
X_1805_ _0913_ _0914_ net123 VGND VGND VPWR VPWR _0915_ sky130_fd_sc_hd__a21o_1
X_1598_ net39 net162 VGND VGND VPWR VPWR _0716_ sky130_fd_sc_hd__nor2_1
X_1667_ net116 _0768_ _0781_ _0782_ VGND VGND VPWR VPWR _0783_ sky130_fd_sc_hd__a22o_1
XFILLER_41_304 VGND VGND VPWR VPWR sky130_fd_sc_hd__fill_2
XTAP_TAPCELL_ROW_51_398 VGND VPWR sky130_fd_sc_hd__tapvpwrvgnd_1
XFILLER_5_238 VGND VGND VPWR VPWR sky130_fd_sc_hd__decap_3
XFILLER_36_109 VPWR VGND VPWR VGND sky130_ef_sc_hd__decap_12
XFILLER_29_161 VGND VGND VPWR VPWR sky130_fd_sc_hd__fill_2
X_1383_ net196 _0507_ _0508_ VGND VGND VPWR VPWR _0509_ sky130_fd_sc_hd__a21oi_1
X_1452_ _0300_ _0575_ net172 VGND VGND VPWR VPWR _0576_ sky130_fd_sc_hd__mux2_1
X_1521_ net36 net136 net131 net215 VGND VGND VPWR VPWR _0642_ sky130_fd_sc_hd__a22oi_1
X_2004_ net57 net138 net133 net235 _0093_ VGND VGND VPWR VPWR _0094_ sky130_fd_sc_hd__a221o_1
XFILLER_27_109 VGND VGND VPWR VPWR sky130_fd_sc_hd__decap_3
X_1719_ net251 net43 net109 VGND VGND VPWR VPWR _0833_ sky130_fd_sc_hd__or3_1
XPHY_EDGE_ROW_16_Left_70 VGND VGND VPWR VPWR sky130_fd_sc_hd__decap_3
XFILLER_41_156 VPWR VGND VPWR VGND sky130_ef_sc_hd__decap_12
XFILLER_26_153 VGND VGND VPWR VPWR sky130_fd_sc_hd__fill_1
Xrebuffer83 net95 VGND VGND VPWR VPWR net335 sky130_fd_sc_hd__dlygate4sd1_1
XFILLER_14_315 VGND VGND VPWR VPWR sky130_fd_sc_hd__fill_1
XFILLER_32_189 VGND VGND VPWR VPWR sky130_fd_sc_hd__fill_2
X_1504_ _0625_ VGND VGND VPWR VPWR _0626_ sky130_fd_sc_hd__inv_2
Xoutput104 net104 VGND VGND VPWR VPWR Result[9] sky130_fd_sc_hd__buf_6
X_1435_ _0558_ VGND VGND VPWR VPWR _0559_ sky130_fd_sc_hd__inv_2
X_1366_ net131 _0490_ VGND VGND VPWR VPWR _0493_ sky130_fd_sc_hd__nand2_1
XTAP_TAPCELL_ROW_53_405 VGND VPWR sky130_fd_sc_hd__tapvpwrvgnd_1
X_1297_ net109 _0425_ VGND VGND VPWR VPWR _0426_ sky130_fd_sc_hd__nor2_1
XFILLER_36_53 VGND VGND VPWR VPWR sky130_fd_sc_hd__decap_8
XPHY_EDGE_ROW_1_Left_55 VGND VGND VPWR VPWR sky130_fd_sc_hd__decap_3
XFILLER_52_41 VPWR VGND VPWR VGND sky130_ef_sc_hd__decap_12
Xinput17 A[24] VGND VGND VPWR VPWR net17 sky130_fd_sc_hd__buf_1
Xinput28 A[5] VGND VGND VPWR VPWR net28 sky130_fd_sc_hd__buf_1
Xinput39 B[15] VGND VGND VPWR VPWR net39 sky130_fd_sc_hd__buf_1
X_1151_ net176 _0282_ VGND VGND VPWR VPWR _0283_ sky130_fd_sc_hd__nand2_1
XFILLER_37_204 VGND VGND VPWR VPWR sky130_fd_sc_hd__decap_8
X_1220_ net115 _0314_ _0349_ _0350_ VGND VGND VPWR VPWR _0351_ sky130_fd_sc_hd__o2bb2ai_1
X_1082_ net249 net248 net247 net246 net221 net212 VGND VGND VPWR VPWR _0215_ sky130_fd_sc_hd__mux4_1
X_1984_ net116 _0063_ _0071_ _0072_ VGND VGND VPWR VPWR _0073_ sky130_fd_sc_hd__a22o_1
XFILLER_9_160 VGND VGND VPWR VPWR sky130_fd_sc_hd__fill_1
XFILLER_20_104 VGND VGND VPWR VPWR sky130_fd_sc_hd__decap_6
XPHY_EDGE_ROW_43_Left_97 VGND VGND VPWR VPWR sky130_fd_sc_hd__decap_3
X_1418_ net227 net30 net29 net28 net217 net208 VGND VGND VPWR VPWR _0543_ sky130_fd_sc_hd__mux4_1
X_1349_ net214 net206 VGND VGND VPWR VPWR _0476_ sky130_fd_sc_hd__or2_1
XFILLER_28_259 VGND VGND VPWR VPWR sky130_fd_sc_hd__fill_1
XFILLER_3_303 VPWR VGND VPWR VGND sky130_ef_sc_hd__decap_12
XFILLER_7_119 VGND VGND VPWR VPWR sky130_fd_sc_hd__fill_2
XFILLER_22_77 VGND VGND VPWR VPWR sky130_fd_sc_hd__decap_6
Xfanout183 net7 VGND VGND VPWR VPWR net183 sky130_fd_sc_hd__buf_2
Xfanout172 _0168_ VGND VGND VPWR VPWR net172 sky130_fd_sc_hd__buf_8
Xfanout161 _0186_ VGND VGND VPWR VPWR net161 sky130_fd_sc_hd__clkbuf_4
Xfanout150 _0196_ VGND VGND VPWR VPWR net150 sky130_fd_sc_hd__clkbuf_4
XFILLER_34_218 VGND VGND VPWR VPWR sky130_fd_sc_hd__decap_4
Xfanout194 net197 VGND VGND VPWR VPWR net194 sky130_fd_sc_hd__dlymetal6s2s_1
XTAP_TAPCELL_ROW_29_276 VGND VPWR sky130_fd_sc_hd__tapvpwrvgnd_1
XFILLER_27_281 VPWR VGND VPWR VGND sky130_ef_sc_hd__decap_12
XFILLER_42_251 VGND VGND VPWR VPWR sky130_fd_sc_hd__fill_1
XFILLER_8_79 VGND VGND VPWR VPWR sky130_fd_sc_hd__fill_1
XFILLER_6_141 VGND VGND VPWR VPWR sky130_fd_sc_hd__fill_2
X_1203_ _0211_ _0228_ net178 VGND VGND VPWR VPWR _0334_ sky130_fd_sc_hd__mux2_1
X_1134_ net180 net146 _0265_ VGND VGND VPWR VPWR _0266_ sky130_fd_sc_hd__o21ai_1
XFILLER_26_3 VPWR VGND VPWR VGND sky130_ef_sc_hd__decap_12
XFILLER_33_295 VGND VGND VPWR VPWR sky130_fd_sc_hd__fill_2
XFILLER_33_240 VPWR VGND VPWR VGND sky130_ef_sc_hd__decap_12
X_1065_ _0110_ _0194_ _0195_ VGND VGND VPWR VPWR _0198_ sky130_fd_sc_hd__or3_1
X_1967_ _0007_ _0054_ net179 VGND VGND VPWR VPWR _0055_ sky130_fd_sc_hd__mux2_1
X_1898_ net112 _0604_ _1003_ net107 VGND VGND VPWR VPWR _1005_ sky130_fd_sc_hd__a211o_1
XFILLER_0_317 VGND VGND VPWR VPWR sky130_fd_sc_hd__fill_1
XTAP_TAPCELL_ROW_3_133 VGND VPWR sky130_fd_sc_hd__tapvpwrvgnd_1
XFILLER_17_55 VGND VGND VPWR VPWR sky130_fd_sc_hd__fill_1
Xclone2 net68 VGND VGND VPWR VPWR net254 sky130_fd_sc_hd__clkbuf_1
XTAP_TAPCELL_ROW_26_257 VGND VPWR sky130_fd_sc_hd__tapvpwrvgnd_1
XFILLER_3_177 VGND VGND VPWR VPWR sky130_fd_sc_hd__fill_2
XFILLER_3_133 VGND VGND VPWR VPWR sky130_fd_sc_hd__decap_8
XFILLER_47_321 VGND VGND VPWR VPWR sky130_fd_sc_hd__fill_1
X_1752_ net46 net149 net144 _0863_ VGND VGND VPWR VPWR _0864_ sky130_fd_sc_hd__a211o_1
X_1683_ net252 _0793_ _0796_ VGND VGND VPWR VPWR _0798_ sky130_fd_sc_hd__mux2_1
X_1821_ _0927_ _0929_ _0930_ _0180_ VGND VGND VPWR VPWR _0931_ sky130_fd_sc_hd__a31o_1
XTAP_TAPCELL_ROW_48_382 VGND VPWR sky130_fd_sc_hd__tapvpwrvgnd_1
X_1117_ net255 net146 _0249_ VGND VGND VPWR VPWR _0250_ sky130_fd_sc_hd__a21o_1
XTAP_TAPCELL_ROW_0_114 VGND VPWR sky130_fd_sc_hd__tapvpwrvgnd_1
XPHY_EDGE_ROW_3_Right_3 VGND VGND VPWR VPWR sky130_fd_sc_hd__decap_3
XFILLER_0_91 VGND VGND VPWR VPWR sky130_fd_sc_hd__decap_6
X_1048_ net186 net185 VGND VGND VPWR VPWR _0181_ sky130_fd_sc_hd__or2_2
XFILLER_29_310 VGND VGND VPWR VPWR sky130_fd_sc_hd__decap_3
XFILLER_44_53 VPWR VGND VPWR VGND sky130_ef_sc_hd__decap_12
XPHY_EDGE_ROW_30_Left_84 VGND VGND VPWR VPWR sky130_fd_sc_hd__decap_3
XFILLER_47_162 VGND VGND VPWR VPWR sky130_fd_sc_hd__fill_1
X_2020_ net94 _0061_ net93 VGND VGND VPWR VPWR _0111_ sky130_fd_sc_hd__mux2_1
XTAP_TAPCELL_ROW_37_319 VGND VPWR sky130_fd_sc_hd__tapvpwrvgnd_1
XTAP_TAPCELL_ROW_45_363 VGND VPWR sky130_fd_sc_hd__tapvpwrvgnd_1
X_1735_ net249 net45 VGND VGND VPWR VPWR _0848_ sky130_fd_sc_hd__or2_1
X_1804_ net48 net138 net130 _0174_ VGND VGND VPWR VPWR _0914_ sky130_fd_sc_hd__o2bb2a_1
X_1666_ net9 net41 VGND VGND VPWR VPWR _0782_ sky130_fd_sc_hd__or2_1
X_1597_ _0694_ _0689_ _0693_ VGND VGND VPWR VPWR _0715_ sky130_fd_sc_hd__a21o_1
XFILLER_53_110 VGND VGND VPWR VPWR sky130_fd_sc_hd__fill_2
XFILLER_5_217 VGND VGND VPWR VPWR sky130_fd_sc_hd__decap_6
XTAP_TAPCELL_ROW_42_344 VGND VPWR sky130_fd_sc_hd__tapvpwrvgnd_1
X_1520_ _0635_ _0640_ VGND VGND VPWR VPWR _0641_ sky130_fd_sc_hd__xnor2_1
X_1382_ _0240_ _0382_ _0386_ _0237_ VGND VGND VPWR VPWR _0508_ sky130_fd_sc_hd__a22o_1
X_1451_ _0574_ _0450_ net199 VGND VGND VPWR VPWR _0575_ sky130_fd_sc_hd__mux2_1
X_2003_ _0091_ _0086_ VGND VGND VPWR VPWR _0093_ sky130_fd_sc_hd__xor2_1
XFILLER_50_179 VPWR VGND VPWR VGND sky130_ef_sc_hd__decap_12
X_1718_ net251 net43 VGND VGND VPWR VPWR _0832_ sky130_fd_sc_hd__nand2_1
X_1649_ _0765_ _0758_ net170 VGND VGND VPWR VPWR _0766_ sky130_fd_sc_hd__a21o_1
XFILLER_41_135 VGND VGND VPWR VPWR sky130_fd_sc_hd__fill_1
XFILLER_41_113 VGND VGND VPWR VPWR sky130_fd_sc_hd__decap_3
XFILLER_26_176 VGND VGND VPWR VPWR sky130_fd_sc_hd__decap_8
XFILLER_41_87 VGND VGND VPWR VPWR sky130_fd_sc_hd__decap_4
XFILLER_2_15 VPWR VGND VPWR VGND sky130_ef_sc_hd__decap_12
XFILLER_17_110 VGND VGND VPWR VPWR sky130_fd_sc_hd__fill_2
XFILLER_40_190 VGND VGND VPWR VPWR sky130_fd_sc_hd__decap_6
XFILLER_32_157 VPWR VGND VPWR VGND sky130_ef_sc_hd__decap_12
XFILLER_9_320 VGND VGND VPWR VPWR sky130_fd_sc_hd__fill_2
Xoutput105 net105 VGND VGND VPWR VPWR V sky130_fd_sc_hd__buf_6
X_1503_ net196 _0375_ _0624_ VGND VGND VPWR VPWR _0625_ sky130_fd_sc_hd__o21a_1
X_1296_ net190 net232 VGND VGND VPWR VPWR _0425_ sky130_fd_sc_hd__or2_1
X_1434_ net225 net151 _0556_ VGND VGND VPWR VPWR _0558_ sky130_fd_sc_hd__and3_1
X_1365_ net139 _0488_ _0490_ VGND VGND VPWR VPWR _0492_ sky130_fd_sc_hd__or3b_1
XTAP_TAPCELL_ROW_53_406 VGND VPWR sky130_fd_sc_hd__tapvpwrvgnd_1
XFILLER_11_308 VGND VGND VPWR VPWR sky130_fd_sc_hd__fill_2
XFILLER_23_113 VGND VGND VPWR VPWR sky130_fd_sc_hd__decap_4
XFILLER_11_57 VPWR VGND VPWR VGND sky130_ef_sc_hd__decap_12
XFILLER_46_249 VGND VGND VPWR VPWR sky130_fd_sc_hd__decap_3
XFILLER_36_65 VGND VGND VPWR VPWR sky130_fd_sc_hd__decap_4
XFILLER_14_102 VGND VGND VPWR VPWR sky130_fd_sc_hd__fill_1
Xinput18 A[25] VGND VGND VPWR VPWR net18 sky130_fd_sc_hd__clkbuf_1
XFILLER_52_53 VGND VGND VPWR VPWR sky130_fd_sc_hd__decap_8
XFILLER_14_124 VGND VGND VPWR VPWR sky130_fd_sc_hd__fill_1
XFILLER_22_190 VGND VGND VPWR VPWR sky130_fd_sc_hd__decap_6
Xinput29 A[6] VGND VGND VPWR VPWR net29 sky130_fd_sc_hd__buf_1
X_1150_ _0280_ _0281_ net203 VGND VGND VPWR VPWR _0282_ sky130_fd_sc_hd__mux2_1
X_1081_ net249 net248 net221 VGND VGND VPWR VPWR _0214_ sky130_fd_sc_hd__mux2_1
XFILLER_9_183 VGND VGND VPWR VPWR sky130_fd_sc_hd__decap_6
XFILLER_9_194 VGND VGND VPWR VPWR sky130_fd_sc_hd__decap_8
XTAP_TAPCELL_ROW_15_196 VGND VPWR sky130_fd_sc_hd__tapvpwrvgnd_1
X_1983_ net237 net56 VGND VGND VPWR VPWR _0072_ sky130_fd_sc_hd__or2_1
X_1417_ net166 _0537_ _0541_ VGND VGND VPWR VPWR _0542_ sky130_fd_sc_hd__a21bo_1
X_1348_ _0323_ _0327_ net205 VGND VGND VPWR VPWR _0475_ sky130_fd_sc_hd__mux2_1
X_1279_ _0402_ _0407_ VGND VGND VPWR VPWR _0408_ sky130_fd_sc_hd__xnor2_1
XFILLER_7_109 VGND VGND VPWR VPWR sky130_fd_sc_hd__decap_3
XFILLER_11_105 VGND VGND VPWR VPWR sky130_fd_sc_hd__decap_6
XFILLER_3_315 VGND VGND VPWR VPWR sky130_fd_sc_hd__decap_6
XFILLER_22_89 VGND VGND VPWR VPWR sky130_fd_sc_hd__fill_1
Xfanout195 net196 VGND VGND VPWR VPWR net195 sky130_fd_sc_hd__buf_6
Xfanout173 _0168_ VGND VGND VPWR VPWR net173 sky130_fd_sc_hd__clkbuf_2
Xfanout184 net257 VGND VGND VPWR VPWR net184 sky130_fd_sc_hd__buf_6
Xfanout151 net153 VGND VGND VPWR VPWR net151 sky130_fd_sc_hd__buf_2
Xfanout162 _0186_ VGND VGND VPWR VPWR net162 sky130_fd_sc_hd__buf_2
Xfanout140 net141 VGND VGND VPWR VPWR net140 sky130_fd_sc_hd__clkbuf_4
XTAP_TAPCELL_ROW_29_277 VGND VPWR sky130_fd_sc_hd__tapvpwrvgnd_1
XFILLER_27_293 VGND VGND VPWR VPWR sky130_fd_sc_hd__decap_6
XFILLER_27_271 VGND VGND VPWR VPWR sky130_fd_sc_hd__decap_8
XFILLER_6_164 VGND VGND VPWR VPWR sky130_fd_sc_hd__fill_1
XFILLER_6_197 VGND VGND VPWR VPWR sky130_fd_sc_hd__decap_4
X_1202_ net242 net229 net215 net207 net219 net210 VGND VGND VPWR VPWR _0333_ sky130_fd_sc_hd__mux4_1
XFILLER_25_219 VGND VGND VPWR VPWR sky130_fd_sc_hd__decap_4
XFILLER_19_3 VPWR VGND VPWR VGND sky130_ef_sc_hd__decap_12
X_1064_ _0195_ _0194_ VGND VGND VPWR VPWR _0197_ sky130_fd_sc_hd__or2_4
X_1133_ net211 _0178_ net272 _0184_ VGND VGND VPWR VPWR _0265_ sky130_fd_sc_hd__a211o_1
X_1966_ net22 net21 net223 VGND VGND VPWR VPWR _0054_ sky130_fd_sc_hd__mux2_1
XFILLER_33_274 VGND VGND VPWR VPWR sky130_fd_sc_hd__decap_6
XFILLER_33_252 VPWR VGND VPWR VGND sky130_ef_sc_hd__decap_12
XFILLER_18_282 VGND VGND VPWR VPWR sky130_fd_sc_hd__fill_2
X_1897_ net181 _0605_ VGND VGND VPWR VPWR _1004_ sky130_fd_sc_hd__and2_1
XTAP_TAPCELL_ROW_3_134 VGND VPWR sky130_fd_sc_hd__tapvpwrvgnd_1
Xclone3 _0189_ VGND VGND VPWR VPWR net255 sky130_fd_sc_hd__clkbuf_1
XTAP_TAPCELL_ROW_26_258 VGND VPWR sky130_fd_sc_hd__tapvpwrvgnd_1
XFILLER_24_241 VGND VGND VPWR VPWR sky130_fd_sc_hd__fill_1
XFILLER_33_55 VGND VGND VPWR VPWR sky130_fd_sc_hd__fill_1
XFILLER_24_285 VPWR VGND VPWR VGND sky130_ef_sc_hd__decap_12
XFILLER_3_167 VGND VGND VPWR VPWR sky130_fd_sc_hd__fill_1
X_1820_ net137 _0924_ _0925_ _0926_ net184 VGND VGND VPWR VPWR _0930_ sky130_fd_sc_hd__a221oi_1
X_1751_ net46 net162 VGND VGND VPWR VPWR _0863_ sky130_fd_sc_hd__nor2_1
X_1682_ _0793_ _0796_ VGND VGND VPWR VPWR _0797_ sky130_fd_sc_hd__nand2_1
XTAP_TAPCELL_ROW_0_115 VGND VPWR sky130_fd_sc_hd__tapvpwrvgnd_1
XFILLER_0_81 VGND VGND VPWR VPWR sky130_fd_sc_hd__decap_3
X_1116_ _0058_ net257 VGND VGND VPWR VPWR _0249_ sky130_fd_sc_hd__nand2_2
X_1047_ net254 net184 VGND VGND VPWR VPWR _0180_ sky130_fd_sc_hd__nor2_2
X_1949_ _0024_ net124 _0031_ _0037_ VGND VGND VPWR VPWR net93 sky130_fd_sc_hd__a211o_1
XFILLER_21_277 VGND VGND VPWR VPWR sky130_fd_sc_hd__decap_3
XFILLER_44_76 VGND VGND VPWR VPWR sky130_fd_sc_hd__fill_2
XFILLER_44_65 VGND VGND VPWR VPWR sky130_fd_sc_hd__fill_2
XFILLER_5_15 VPWR VGND VPWR VGND sky130_ef_sc_hd__decap_12
XFILLER_35_303 VGND VGND VPWR VPWR sky130_fd_sc_hd__fill_1
XPHY_EDGE_ROW_13_Right_13 VGND VGND VPWR VPWR sky130_fd_sc_hd__decap_3
XTAP_TAPCELL_ROW_45_364 VGND VPWR sky130_fd_sc_hd__tapvpwrvgnd_1
X_1803_ _0907_ _0912_ VGND VGND VPWR VPWR _0913_ sky130_fd_sc_hd__xor2_1
XPHY_EDGE_ROW_22_Right_22 VGND VGND VPWR VPWR sky130_fd_sc_hd__decap_3
X_1596_ _0714_ VGND VGND VPWR VPWR net78 sky130_fd_sc_hd__inv_2
X_1734_ net249 net45 VGND VGND VPWR VPWR _0847_ sky130_fd_sc_hd__nand2_1
XFILLER_7_270 VGND VGND VPWR VPWR sky130_fd_sc_hd__decap_8
X_1665_ net9 net41 VGND VGND VPWR VPWR _0781_ sky130_fd_sc_hd__nand2_1
XPHY_EDGE_ROW_31_Right_31 VGND VGND VPWR VPWR sky130_fd_sc_hd__decap_3
XFILLER_41_317 VGND VGND VPWR VPWR sky130_fd_sc_hd__fill_2
XFILLER_38_174 VPWR VGND VPWR VGND sky130_ef_sc_hd__decap_12
XPHY_EDGE_ROW_40_Right_40 VGND VGND VPWR VPWR sky130_fd_sc_hd__decap_3
XFILLER_30_12 VPWR VGND VPWR VGND sky130_ef_sc_hd__decap_12
XFILLER_30_67 VGND VGND VPWR VPWR sky130_fd_sc_hd__decap_4
XFILLER_29_141 VPWR VGND VPWR VGND sky130_ef_sc_hd__decap_12
XTAP_TAPCELL_ROW_42_345 VGND VPWR sky130_fd_sc_hd__tapvpwrvgnd_1
X_1450_ net226 net31 net30 net29 net217 net208 VGND VGND VPWR VPWR _0574_ sky130_fd_sc_hd__mux4_1
X_1381_ _0383_ _0378_ net203 VGND VGND VPWR VPWR _0507_ sky130_fd_sc_hd__mux2_1
X_2002_ _0086_ _0091_ VGND VGND VPWR VPWR _0092_ sky130_fd_sc_hd__nor2_1
X_1579_ _0654_ _0697_ net180 VGND VGND VPWR VPWR _0698_ sky130_fd_sc_hd__mux2_1
X_1717_ net251 net119 _0830_ net162 VGND VGND VPWR VPWR _0831_ sky130_fd_sc_hd__o22a_1
X_1648_ _0750_ net124 _0764_ net184 VGND VGND VPWR VPWR _0765_ sky130_fd_sc_hd__a22oi_1
Xrebuffer30 _0183_ VGND VGND VPWR VPWR net282 sky130_fd_sc_hd__dlygate4sd1_1
XFILLER_41_169 VPWR VGND VPWR VGND sky130_ef_sc_hd__decap_12
XFILLER_26_188 VGND VGND VPWR VPWR sky130_fd_sc_hd__fill_1
XFILLER_41_55 VGND VGND VPWR VPWR sky130_fd_sc_hd__fill_1
XFILLER_1_210 VGND VGND VPWR VPWR sky130_fd_sc_hd__fill_1
XFILLER_2_27 VGND VGND VPWR VPWR sky130_fd_sc_hd__fill_1
XFILLER_17_100 VGND VGND VPWR VPWR sky130_fd_sc_hd__decap_3
XFILLER_32_169 VPWR VGND VPWR VGND sky130_ef_sc_hd__decap_12
XFILLER_49_3 VPWR VGND VPWR VGND sky130_ef_sc_hd__decap_12
X_1502_ net171 _0368_ VGND VGND VPWR VPWR _0624_ sky130_fd_sc_hd__nand2_1
Xoutput106 net106 VGND VGND VPWR VPWR Z sky130_fd_sc_hd__buf_6
X_1433_ net225 _0556_ net151 VGND VGND VPWR VPWR _0557_ sky130_fd_sc_hd__o21a_1
X_1295_ _0190_ _0423_ _0421_ _0225_ VGND VGND VPWR VPWR _0424_ sky130_fd_sc_hd__a211o_1
X_1364_ net115 _0467_ _0489_ _0490_ VGND VGND VPWR VPWR _0491_ sky130_fd_sc_hd__a22o_1
XTAP_TAPCELL_ROW_53_407 VGND VPWR sky130_fd_sc_hd__tapvpwrvgnd_1
XFILLER_11_69 VPWR VGND VPWR VGND sky130_ef_sc_hd__decap_12
XFILLER_46_228 VGND VGND VPWR VPWR sky130_fd_sc_hd__decap_3
XFILLER_39_291 VGND VGND VPWR VPWR sky130_fd_sc_hd__decap_8
Xinput19 A[26] VGND VGND VPWR VPWR net19 sky130_fd_sc_hd__clkbuf_1
X_1080_ _0211_ _0212_ net213 VGND VGND VPWR VPWR _0213_ sky130_fd_sc_hd__mux2_1
X_1982_ net237 net56 VGND VGND VPWR VPWR _0071_ sky130_fd_sc_hd__nand2_1
XTAP_TAPCELL_ROW_15_197 VGND VPWR sky130_fd_sc_hd__tapvpwrvgnd_1
X_1347_ _0472_ _0473_ net122 VGND VGND VPWR VPWR _0474_ sky130_fd_sc_hd__a21o_1
X_1416_ net227 net118 net109 _0537_ _0540_ VGND VGND VPWR VPWR _0541_ sky130_fd_sc_hd__o221a_1
X_1278_ _0405_ _0406_ VGND VGND VPWR VPWR _0407_ sky130_fd_sc_hd__nor2_1
Xfanout174 _0168_ VGND VGND VPWR VPWR net174 sky130_fd_sc_hd__buf_2
Xfanout196 net197 VGND VGND VPWR VPWR net196 sky130_fd_sc_hd__buf_4
Xfanout141 _0200_ VGND VGND VPWR VPWR net141 sky130_fd_sc_hd__clkbuf_4
Xfanout152 net153 VGND VGND VPWR VPWR net152 sky130_fd_sc_hd__clkbuf_2
Xfanout163 _0186_ VGND VGND VPWR VPWR net163 sky130_fd_sc_hd__clkbuf_2
Xfanout130 _0209_ VGND VGND VPWR VPWR net130 sky130_fd_sc_hd__buf_2
Xfanout185 net69 VGND VGND VPWR VPWR net185 sky130_fd_sc_hd__buf_8
XFILLER_34_209 VGND VGND VPWR VPWR sky130_fd_sc_hd__fill_1
XFILLER_8_15 VPWR VGND VPWR VGND sky130_ef_sc_hd__decap_12
XFILLER_6_132 VGND VGND VPWR VPWR sky130_fd_sc_hd__decap_8
XFILLER_10_161 VGND VGND VPWR VPWR sky130_fd_sc_hd__decap_3
XFILLER_10_194 VGND VGND VPWR VPWR sky130_fd_sc_hd__fill_2
X_1201_ net158 _0330_ _0331_ net166 VGND VGND VPWR VPWR _0332_ sky130_fd_sc_hd__a22o_1
X_1132_ _0181_ net117 _0203_ _0202_ _0089_ VGND VGND VPWR VPWR _0264_ sky130_fd_sc_hd__o32ai_4
X_1063_ _0194_ _0195_ VGND VGND VPWR VPWR _0196_ sky130_fd_sc_hd__nor2_1
XFILLER_33_264 VGND VGND VPWR VPWR sky130_fd_sc_hd__decap_3
X_1965_ net239 net120 _0049_ net164 _0052_ VGND VGND VPWR VPWR _0053_ sky130_fd_sc_hd__o221a_1
X_1896_ net172 _0803_ _1002_ net113 VGND VGND VPWR VPWR _1003_ sky130_fd_sc_hd__o211a_1
XTAP_TAPCELL_ROW_26_259 VGND VPWR sky130_fd_sc_hd__tapvpwrvgnd_1
Xclone4 _0187_ VGND VGND VPWR VPWR net256 sky130_fd_sc_hd__clkbuf_1
XFILLER_24_297 VGND VGND VPWR VPWR sky130_fd_sc_hd__decap_8
XFILLER_3_146 VGND VGND VPWR VPWR sky130_fd_sc_hd__decap_8
XFILLER_30_245 VGND VGND VPWR VPWR sky130_fd_sc_hd__decap_3
XFILLER_30_201 VGND VGND VPWR VPWR sky130_fd_sc_hd__decap_4
X_1750_ _0172_ _0841_ _0842_ _0838_ VGND VGND VPWR VPWR _0862_ sky130_fd_sc_hd__a2bb2o_4
XFILLER_15_286 VPWR VGND VPWR VGND sky130_ef_sc_hd__decap_12
X_1681_ net154 _0795_ VGND VGND VPWR VPWR _0796_ sky130_fd_sc_hd__nand2_1
XFILLER_31_3 VPWR VGND VPWR VGND sky130_ef_sc_hd__decap_12
XTAP_TAPCELL_ROW_0_116 VGND VPWR sky130_fd_sc_hd__tapvpwrvgnd_1
X_1046_ net38 VGND VGND VPWR VPWR _0179_ sky130_fd_sc_hd__inv_2
XFILLER_21_201 VGND VGND VPWR VPWR sky130_fd_sc_hd__decap_8
X_1115_ net254 _0068_ VGND VGND VPWR VPWR _0248_ sky130_fd_sc_hd__nor2_4
X_1948_ _0035_ _0036_ _0248_ VGND VGND VPWR VPWR _0037_ sky130_fd_sc_hd__o21a_1
XTAP_TAPCELL_ROW_31_284 VGND VPWR sky130_fd_sc_hd__tapvpwrvgnd_1
X_1879_ net156 _0985_ VGND VGND VPWR VPWR _0986_ sky130_fd_sc_hd__nand2_1
XFILLER_0_138 VGND VGND VPWR VPWR sky130_fd_sc_hd__fill_2
XFILLER_28_67 VGND VGND VPWR VPWR sky130_fd_sc_hd__fill_2
XFILLER_8_216 VGND VGND VPWR VPWR sky130_fd_sc_hd__fill_1
XFILLER_5_27 VPWR VGND VPWR VGND sky130_ef_sc_hd__decap_12
XTAP_TAPCELL_ROW_45_365 VGND VPWR sky130_fd_sc_hd__tapvpwrvgnd_1
X_1733_ _0845_ _0844_ VGND VGND VPWR VPWR _0846_ sky130_fd_sc_hd__nand2_2
X_1802_ _0174_ _0910_ _0911_ VGND VGND VPWR VPWR _0912_ sky130_fd_sc_hd__o21ai_1
X_1664_ _0358_ _0575_ _0779_ _0344_ _0294_ VGND VGND VPWR VPWR _0780_ sky130_fd_sc_hd__a221o_1
X_1595_ _0696_ net122 _0704_ _0713_ VGND VGND VPWR VPWR _0714_ sky130_fd_sc_hd__o211a_4
XFILLER_38_186 VGND VGND VPWR VPWR sky130_fd_sc_hd__decap_6
X_1029_ net225 VGND VGND VPWR VPWR _0162_ sky130_fd_sc_hd__inv_2
XFILLER_14_69 VGND VGND VPWR VPWR sky130_fd_sc_hd__fill_1
XFILLER_30_24 VGND VGND VPWR VPWR sky130_fd_sc_hd__decap_4
XFILLER_39_55 VGND VGND VPWR VPWR sky130_fd_sc_hd__fill_1
XFILLER_44_178 VPWR VGND VPWR VGND sky130_ef_sc_hd__decap_12
XFILLER_29_153 VGND VGND VPWR VPWR sky130_fd_sc_hd__decap_8
XTAP_TAPCELL_ROW_50_390 VGND VPWR sky130_fd_sc_hd__tapvpwrvgnd_1
XTAP_TAPCELL_ROW_42_346 VGND VPWR sky130_fd_sc_hd__tapvpwrvgnd_1
XFILLER_4_274 VPWR VGND VPWR VGND sky130_ef_sc_hd__decap_12
X_1380_ _0504_ _0505_ net122 VGND VGND VPWR VPWR _0506_ sky130_fd_sc_hd__a21o_1
X_2001_ net234 _0180_ _0088_ _0090_ VGND VGND VPWR VPWR _0091_ sky130_fd_sc_hd__a31o_1
XFILLER_50_104 VGND VGND VPWR VPWR sky130_fd_sc_hd__decap_3
XFILLER_35_189 VGND VGND VPWR VPWR sky130_fd_sc_hd__fill_1
XFILLER_35_167 VGND VGND VPWR VPWR sky130_fd_sc_hd__fill_1
XFILLER_23_318 VGND VGND VPWR VPWR sky130_fd_sc_hd__decap_4
X_1716_ net251 net43 VGND VGND VPWR VPWR _0830_ sky130_fd_sc_hd__nor2_1
X_1578_ net6 net5 net219 VGND VGND VPWR VPWR _0697_ sky130_fd_sc_hd__mux2_1
X_1647_ net195 net113 _0544_ _0763_ VGND VGND VPWR VPWR _0764_ sky130_fd_sc_hd__a31o_1
Xrebuffer31 _0933_ VGND VGND VPWR VPWR net283 sky130_fd_sc_hd__dlygate4sd1_1
XFILLER_14_307 VGND VGND VPWR VPWR sky130_fd_sc_hd__fill_1
XFILLER_25_57 VGND VGND VPWR VPWR sky130_fd_sc_hd__fill_1
XFILLER_9_3 VPWR VGND VPWR VGND sky130_ef_sc_hd__decap_12
XFILLER_1_255 VPWR VGND VPWR VGND sky130_ef_sc_hd__decap_12
X_1432_ net64 net147 net142 _0555_ VGND VGND VPWR VPWR _0556_ sky130_fd_sc_hd__a211o_1
X_1501_ net229 net118 _0619_ net160 _0622_ VGND VGND VPWR VPWR _0623_ sky130_fd_sc_hd__o221a_1
X_1363_ net230 net61 VGND VGND VPWR VPWR _0490_ sky130_fd_sc_hd__nand2_1
XTAP_TAPCELL_ROW_53_408 VGND VPWR sky130_fd_sc_hd__tapvpwrvgnd_1
X_1294_ _0227_ _0240_ _0418_ net195 _0422_ VGND VGND VPWR VPWR _0423_ sky130_fd_sc_hd__a221o_1
XFILLER_23_104 VGND VGND VPWR VPWR sky130_fd_sc_hd__decap_3
XPHY_EDGE_ROW_52_Left_106 VGND VGND VPWR VPWR sky130_fd_sc_hd__decap_3
XFILLER_11_15 VPWR VGND VPWR VGND sky130_ef_sc_hd__decap_12
XFILLER_11_48 VGND VGND VPWR VPWR sky130_fd_sc_hd__fill_1
XFILLER_36_89 VGND VGND VPWR VPWR sky130_fd_sc_hd__decap_3
XTAP_TAPCELL_ROW_9_163 VGND VPWR sky130_fd_sc_hd__tapvpwrvgnd_1
X_1981_ net56 net138 net133 net237 _0069_ VGND VGND VPWR VPWR _0070_ sky130_fd_sc_hd__a221o_1
XTAP_TAPCELL_ROW_15_198 VGND VPWR sky130_fd_sc_hd__tapvpwrvgnd_1
X_1346_ net61 net135 net127 _0159_ VGND VGND VPWR VPWR _0473_ sky130_fd_sc_hd__o2bb2a_1
X_1415_ net108 _0539_ _0538_ VGND VGND VPWR VPWR _0540_ sky130_fd_sc_hd__mux2_1
XFILLER_36_295 VGND VGND VPWR VPWR sky130_fd_sc_hd__fill_1
X_1277_ net232 net153 _0404_ VGND VGND VPWR VPWR _0406_ sky130_fd_sc_hd__and3_1
XFILLER_51_276 VGND VGND VPWR VPWR sky130_fd_sc_hd__decap_4
XFILLER_51_265 VGND VGND VPWR VPWR sky130_fd_sc_hd__decap_3
Xfanout131 net133 VGND VGND VPWR VPWR net131 sky130_fd_sc_hd__clkbuf_4
Xfanout120 net121 VGND VGND VPWR VPWR net120 sky130_fd_sc_hd__clkbuf_2
XPHY_EDGE_ROW_5_Left_59 VGND VGND VPWR VPWR sky130_fd_sc_hd__decap_3
Xfanout175 _0168_ VGND VGND VPWR VPWR net175 sky130_fd_sc_hd__buf_2
XFILLER_47_55 VGND VGND VPWR VPWR sky130_fd_sc_hd__fill_1
Xfanout153 _0192_ VGND VGND VPWR VPWR net153 sky130_fd_sc_hd__buf_2
Xfanout142 net143 VGND VGND VPWR VPWR net142 sky130_fd_sc_hd__clkbuf_4
Xfanout164 net165 VGND VGND VPWR VPWR net164 sky130_fd_sc_hd__buf_2
Xfanout186 net68 VGND VGND VPWR VPWR net186 sky130_fd_sc_hd__buf_8
Xfanout197 net58 VGND VGND VPWR VPWR net197 sky130_fd_sc_hd__buf_4
XFILLER_42_287 VGND VGND VPWR VPWR sky130_fd_sc_hd__decap_4
XFILLER_42_265 VGND VGND VPWR VPWR sky130_fd_sc_hd__decap_4
XFILLER_8_27 VGND VGND VPWR VPWR sky130_fd_sc_hd__fill_1
XTAP_TAPCELL_ROW_12_179 VGND VPWR sky130_fd_sc_hd__tapvpwrvgnd_1
X_1200_ net193 _0328_ _0325_ VGND VGND VPWR VPWR _0331_ sky130_fd_sc_hd__a21o_1
X_1131_ _0247_ _0250_ _0263_ VGND VGND VPWR VPWR net73 sky130_fd_sc_hd__o21ai_4
XFILLER_18_251 VGND VGND VPWR VPWR sky130_fd_sc_hd__fill_1
X_1062_ net186 net185 net188 VGND VGND VPWR VPWR _0195_ sky130_fd_sc_hd__a21boi_2
X_1895_ _0241_ _0895_ _1001_ net171 VGND VGND VPWR VPWR _1002_ sky130_fd_sc_hd__o22a_1
X_1964_ net239 net54 net110 _0048_ _0051_ VGND VGND VPWR VPWR _0052_ sky130_fd_sc_hd__o311a_1
Xclone5 net69 VGND VGND VPWR VPWR net257 sky130_fd_sc_hd__buf_2
X_1329_ net231 net60 VGND VGND VPWR VPWR _0457_ sky130_fd_sc_hd__nor2_1
XFILLER_33_57 VPWR VGND VPWR VGND sky130_ef_sc_hd__decap_12
XFILLER_3_169 VGND VGND VPWR VPWR sky130_fd_sc_hd__decap_8
X_1680_ net42 net149 net144 _0794_ VGND VGND VPWR VPWR _0795_ sky130_fd_sc_hd__a211o_1
X_1114_ net192 _0233_ net171 _0246_ VGND VGND VPWR VPWR _0247_ sky130_fd_sc_hd__o31a_1
XTAP_TAPCELL_ROW_0_117 VGND VPWR sky130_fd_sc_hd__tapvpwrvgnd_1
XFILLER_0_61 VGND VGND VPWR VPWR sky130_fd_sc_hd__decap_6
X_1045_ net66 VGND VGND VPWR VPWR _0178_ sky130_fd_sc_hd__inv_2
X_1947_ net182 _0652_ _0657_ net112 net107 VGND VGND VPWR VPWR _0036_ sky130_fd_sc_hd__a221o_1
XTAP_TAPCELL_ROW_31_285 VGND VPWR sky130_fd_sc_hd__tapvpwrvgnd_1
X_1878_ net51 net164 net141 _0984_ VGND VGND VPWR VPWR _0985_ sky130_fd_sc_hd__o211ai_1
XFILLER_0_117 VGND VGND VPWR VPWR sky130_fd_sc_hd__fill_1
XTAP_TAPCELL_ROW_39_330 VGND VPWR sky130_fd_sc_hd__tapvpwrvgnd_1
XFILLER_28_35 VGND VGND VPWR VPWR sky130_fd_sc_hd__fill_1
XFILLER_5_39 VPWR VGND VPWR VGND sky130_ef_sc_hd__decap_12
XFILLER_47_110 VGND VGND VPWR VPWR sky130_fd_sc_hd__fill_2
XPHY_EDGE_ROW_8_Left_62 VGND VGND VPWR VPWR sky130_fd_sc_hd__decap_3
X_1663_ _0778_ _0683_ net201 VGND VGND VPWR VPWR _0779_ sky130_fd_sc_hd__mux2_1
X_1732_ net45 net137 net129 _0172_ VGND VGND VPWR VPWR _0845_ sky130_fd_sc_hd__o2bb2a_1
XFILLER_7_250 VGND VGND VPWR VPWR sky130_fd_sc_hd__decap_8
X_1801_ net246 _0909_ net155 VGND VGND VPWR VPWR _0911_ sky130_fd_sc_hd__o21a_1
XPHY_EDGE_ROW_7_Right_7 VGND VGND VPWR VPWR sky130_fd_sc_hd__decap_3
X_1594_ _0708_ _0710_ _0712_ net126 VGND VGND VPWR VPWR _0713_ sky130_fd_sc_hd__a31o_1
XFILLER_38_110 VGND VGND VPWR VPWR sky130_fd_sc_hd__decap_6
XTAP_TAPCELL_ROW_36_311 VGND VPWR sky130_fd_sc_hd__tapvpwrvgnd_1
X_1028_ net227 VGND VGND VPWR VPWR _0161_ sky130_fd_sc_hd__inv_2
XFILLER_14_15 VPWR VGND VPWR VGND sky130_ef_sc_hd__decap_12
XPHY_EDGE_ROW_34_Left_88 VGND VGND VPWR VPWR sky130_fd_sc_hd__decap_3
XFILLER_32_319 VGND VGND VPWR VPWR sky130_fd_sc_hd__decap_3
XTAP_TAPCELL_ROW_50_391 VGND VPWR sky130_fd_sc_hd__tapvpwrvgnd_1
XTAP_TAPCELL_ROW_42_347 VGND VPWR sky130_fd_sc_hd__tapvpwrvgnd_1
XFILLER_4_286 VPWR VGND VPWR VGND sky130_ef_sc_hd__decap_12
XFILLER_4_253 VGND VGND VPWR VPWR sky130_fd_sc_hd__decap_4
XFILLER_20_80 VGND VGND VPWR VPWR sky130_fd_sc_hd__decap_4
XFILLER_35_135 VGND VGND VPWR VPWR sky130_fd_sc_hd__decap_6
X_2000_ net234 _0088_ net157 VGND VGND VPWR VPWR _0090_ sky130_fd_sc_hd__o21ai_1
XFILLER_23_308 VGND VGND VPWR VPWR sky130_fd_sc_hd__fill_1
X_1646_ _0224_ net111 _0762_ net174 net107 VGND VGND VPWR VPWR _0763_ sky130_fd_sc_hd__a221o_1
X_1715_ _0823_ _0828_ net184 VGND VGND VPWR VPWR _0829_ sky130_fd_sc_hd__o21ai_1
X_1577_ _0179_ _0207_ net127 _0166_ _0695_ VGND VGND VPWR VPWR _0696_ sky130_fd_sc_hd__o221a_1
Xrebuffer54 _0837_ VGND VGND VPWR VPWR net306 sky130_fd_sc_hd__dlymetal6s2s_1
XFILLER_26_168 VGND VGND VPWR VPWR sky130_fd_sc_hd__fill_2
XFILLER_25_47 VGND VGND VPWR VPWR sky130_fd_sc_hd__fill_1
Xrebuffer76 _0689_ VGND VGND VPWR VPWR net328 sky130_fd_sc_hd__dlygate4sd1_1
Xrebuffer21 _0838_ VGND VGND VPWR VPWR net273 sky130_fd_sc_hd__dlygate4sd1_1
XFILLER_14_319 VGND VGND VPWR VPWR sky130_fd_sc_hd__decap_3
XFILLER_34_190 VGND VGND VPWR VPWR sky130_fd_sc_hd__fill_1
XFILLER_1_267 VPWR VGND VPWR VGND sky130_ef_sc_hd__decap_12
XFILLER_1_223 VGND VGND VPWR VPWR sky130_fd_sc_hd__fill_1
XFILLER_49_249 VGND VGND VPWR VPWR sky130_fd_sc_hd__fill_2
XFILLER_49_216 VGND VGND VPWR VPWR sky130_fd_sc_hd__fill_1
XFILLER_2_29 VPWR VGND VPWR VGND sky130_ef_sc_hd__decap_12
XFILLER_32_149 VGND VGND VPWR VPWR sky130_fd_sc_hd__fill_1
XFILLER_17_157 VGND VGND VPWR VPWR sky130_fd_sc_hd__decap_3
X_1500_ net229 net35 net109 _0618_ _0621_ VGND VGND VPWR VPWR _0622_ sky130_fd_sc_hd__o311a_1
X_1293_ _0237_ _0243_ VGND VGND VPWR VPWR _0422_ sky130_fd_sc_hd__and2_1
Xoutput90 net90 VGND VGND VPWR VPWR Result[25] sky130_fd_sc_hd__buf_6
X_1431_ net64 net159 VGND VGND VPWR VPWR _0555_ sky130_fd_sc_hd__nor2_1
X_1362_ net230 net61 VGND VGND VPWR VPWR _0489_ sky130_fd_sc_hd__or2_1
XTAP_TAPCELL_ROW_53_409 VGND VPWR sky130_fd_sc_hd__tapvpwrvgnd_1
XFILLER_48_260 VGND VGND VPWR VPWR sky130_fd_sc_hd__decap_4
XFILLER_16_190 VGND VGND VPWR VPWR sky130_fd_sc_hd__fill_1
XFILLER_11_27 VPWR VGND VPWR VGND sky130_ef_sc_hd__decap_12
X_1629_ net8 _0744_ net154 VGND VGND VPWR VPWR _0746_ sky130_fd_sc_hd__o21a_1
XFILLER_36_79 VGND VGND VPWR VPWR sky130_fd_sc_hd__decap_4
XFILLER_52_89 VGND VGND VPWR VPWR sky130_fd_sc_hd__decap_6
XTAP_TAPCELL_ROW_9_164 VGND VPWR sky130_fd_sc_hd__tapvpwrvgnd_1
XPHY_EDGE_ROW_37_Left_91 VGND VGND VPWR VPWR sky130_fd_sc_hd__decap_3
X_1980_ _0062_ _0067_ VGND VGND VPWR VPWR _0069_ sky130_fd_sc_hd__xor2_1
XFILLER_9_131 VPWR VGND VPWR VGND sky130_ef_sc_hd__decap_12
XTAP_TAPCELL_ROW_15_199 VGND VPWR sky130_fd_sc_hd__tapvpwrvgnd_1
XPHY_EDGE_ROW_21_Left_75 VGND VGND VPWR VPWR sky130_fd_sc_hd__decap_3
Xrebuffer1 _0187_ VGND VGND VPWR VPWR net253 sky130_fd_sc_hd__dlygate4sd1_1
XFILLER_28_208 VPWR VGND VPWR VGND sky130_ef_sc_hd__decap_12
X_1414_ net142 _0537_ net131 VGND VGND VPWR VPWR _0539_ sky130_fd_sc_hd__a21oi_1
X_1345_ _0466_ _0471_ VGND VGND VPWR VPWR _0472_ sky130_fd_sc_hd__xor2_1
X_1276_ net232 _0404_ net153 VGND VGND VPWR VPWR _0405_ sky130_fd_sc_hd__o21ai_1
XFILLER_36_241 VGND VGND VPWR VPWR sky130_fd_sc_hd__fill_1
XFILLER_22_15 VPWR VGND VPWR VGND sky130_ef_sc_hd__decap_12
Xfanout110 _0258_ VGND VGND VPWR VPWR net110 sky130_fd_sc_hd__clkbuf_2
Xfanout143 _0199_ VGND VGND VPWR VPWR net143 sky130_fd_sc_hd__clkbuf_2
Xfanout154 net156 VGND VGND VPWR VPWR net154 sky130_fd_sc_hd__buf_2
Xfanout121 _0188_ VGND VGND VPWR VPWR net121 sky130_fd_sc_hd__buf_4
Xfanout165 _0186_ VGND VGND VPWR VPWR net165 sky130_fd_sc_hd__clkbuf_2
Xfanout132 net133 VGND VGND VPWR VPWR net132 sky130_fd_sc_hd__clkbuf_4
Xfanout176 _0168_ VGND VGND VPWR VPWR net176 sky130_fd_sc_hd__clkbuf_2
Xfanout198 net199 VGND VGND VPWR VPWR net198 sky130_fd_sc_hd__buf_2
Xfanout187 net188 VGND VGND VPWR VPWR net187 sky130_fd_sc_hd__buf_8
XFILLER_10_174 VPWR VGND VPWR VGND sky130_ef_sc_hd__decap_12
X_1130_ _0180_ _0210_ net126 _0262_ VGND VGND VPWR VPWR _0263_ sky130_fd_sc_hd__o2bb2a_1
XFILLER_18_296 VGND VGND VPWR VPWR sky130_fd_sc_hd__decap_3
X_1061_ net186 net185 net65 net66 VGND VGND VPWR VPWR _0194_ sky130_fd_sc_hd__o2bb2a_4
X_1894_ _0950_ _1000_ net179 VGND VGND VPWR VPWR _1001_ sky130_fd_sc_hd__mux2_1
X_1963_ net239 net54 _0050_ VGND VGND VPWR VPWR _0051_ sky130_fd_sc_hd__a21o_1
X_1259_ net198 _0388_ VGND VGND VPWR VPWR _0389_ sky130_fd_sc_hd__nand2b_1
X_1328_ net181 _0448_ _0455_ _0248_ VGND VGND VPWR VPWR _0456_ sky130_fd_sc_hd__o211ai_1
XFILLER_17_15 VPWR VGND VPWR VGND sky130_ef_sc_hd__decap_12
XFILLER_33_69 VGND VGND VPWR VPWR sky130_fd_sc_hd__fill_1
XFILLER_15_222 VGND VGND VPWR VPWR sky130_fd_sc_hd__fill_2
XFILLER_15_255 VGND VGND VPWR VPWR sky130_fd_sc_hd__fill_1
XFILLER_15_277 VGND VGND VPWR VPWR sky130_fd_sc_hd__decap_3
XFILLER_2_192 VGND VGND VPWR VPWR sky130_fd_sc_hd__decap_4
X_1113_ _0224_ _0225_ net111 _0244_ VGND VGND VPWR VPWR _0246_ sky130_fd_sc_hd__a22oi_1
XTAP_TAPCELL_ROW_0_118 VGND VPWR sky130_fd_sc_hd__tapvpwrvgnd_1
XFILLER_0_51 VGND VGND VPWR VPWR sky130_fd_sc_hd__decap_4
XFILLER_17_3 VPWR VGND VPWR VGND sky130_ef_sc_hd__decap_12
X_1044_ net241 VGND VGND VPWR VPWR _0177_ sky130_fd_sc_hd__inv_2
XFILLER_21_236 VGND VGND VPWR VPWR sky130_fd_sc_hd__decap_4
X_1946_ net171 _0033_ _0034_ VGND VGND VPWR VPWR _0035_ sky130_fd_sc_hd__o21a_1
XTAP_TAPCELL_ROW_31_286 VGND VPWR sky130_fd_sc_hd__tapvpwrvgnd_1
X_1877_ net51 net150 VGND VGND VPWR VPWR _0984_ sky130_fd_sc_hd__nand2_1
XTAP_TAPCELL_ROW_39_331 VGND VPWR sky130_fd_sc_hd__tapvpwrvgnd_1
XFILLER_47_166 VGND VGND VPWR VPWR sky130_fd_sc_hd__fill_2
XFILLER_50_309 VPWR VGND VPWR VGND sky130_ef_sc_hd__decap_12
X_1800_ net155 _0909_ VGND VGND VPWR VPWR _0910_ sky130_fd_sc_hd__nand2_1
X_1662_ _0733_ _0777_ net178 VGND VGND VPWR VPWR _0778_ sky130_fd_sc_hd__mux2_1
X_1731_ net273 _0843_ VGND VGND VPWR VPWR _0844_ sky130_fd_sc_hd__xor2_1
X_1593_ net134 _0706_ _0709_ _0711_ VGND VGND VPWR VPWR _0712_ sky130_fd_sc_hd__o211a_1
XTAP_TAPCELL_ROW_36_312 VGND VPWR sky130_fd_sc_hd__tapvpwrvgnd_1
X_1027_ net228 VGND VGND VPWR VPWR _0160_ sky130_fd_sc_hd__inv_2
X_1929_ net240 _0017_ net157 VGND VGND VPWR VPWR _0018_ sky130_fd_sc_hd__o21a_1
XFILLER_14_27 VGND VGND VPWR VPWR sky130_fd_sc_hd__fill_1
XFILLER_39_57 VGND VGND VPWR VPWR sky130_fd_sc_hd__fill_1
XFILLER_29_111 VGND VGND VPWR VPWR sky130_fd_sc_hd__fill_1
XTAP_TAPCELL_ROW_42_348 VGND VPWR sky130_fd_sc_hd__tapvpwrvgnd_1
XFILLER_32_309 VGND VGND VPWR VPWR sky130_fd_sc_hd__fill_1
XTAP_TAPCELL_ROW_50_392 VGND VPWR sky130_fd_sc_hd__tapvpwrvgnd_1
XFILLER_4_232 VPWR VGND VPWR VGND sky130_ef_sc_hd__decap_12
XFILLER_4_298 VGND VGND VPWR VPWR sky130_fd_sc_hd__decap_8
XFILLER_20_92 VPWR VGND VPWR VGND sky130_ef_sc_hd__decap_12
XFILLER_35_169 VPWR VGND VPWR VGND sky130_ef_sc_hd__decap_12
XFILLER_29_90 VGND VGND VPWR VPWR sky130_fd_sc_hd__fill_1
XFILLER_50_139 VGND VGND VPWR VPWR sky130_fd_sc_hd__fill_1
X_1714_ net192 _0381_ _0827_ net114 VGND VGND VPWR VPWR _0828_ sky130_fd_sc_hd__a2bb2o_1
X_1645_ _0245_ net112 _0761_ net113 VGND VGND VPWR VPWR _0762_ sky130_fd_sc_hd__a22o_1
X_1576_ net328 _0694_ VGND VGND VPWR VPWR _0695_ sky130_fd_sc_hd__xnor2_2
XFILLER_25_15 VGND VGND VPWR VPWR sky130_fd_sc_hd__decap_3
Xrebuffer22 _0742_ VGND VGND VPWR VPWR net274 sky130_fd_sc_hd__dlygate4sd1_1
XFILLER_14_309 VGND VGND VPWR VPWR sky130_fd_sc_hd__decap_6
X_2059_ net74 net75 _0123_ _0151_ VGND VGND VPWR VPWR _0152_ sky130_fd_sc_hd__or4_1
XFILLER_1_279 VGND VGND VPWR VPWR sky130_fd_sc_hd__fill_1
XFILLER_1_235 VGND VGND VPWR VPWR sky130_fd_sc_hd__fill_1
XFILLER_1_202 VGND VGND VPWR VPWR sky130_fd_sc_hd__fill_1
XFILLER_40_172 VGND VGND VPWR VPWR sky130_fd_sc_hd__decap_6
XFILLER_32_139 VGND VGND VPWR VPWR sky130_fd_sc_hd__fill_1
XFILLER_13_320 VGND VGND VPWR VPWR sky130_fd_sc_hd__fill_2
XFILLER_15_70 VGND VGND VPWR VPWR sky130_fd_sc_hd__fill_2
X_1430_ _0161_ _0531_ _0532_ _0528_ VGND VGND VPWR VPWR _0554_ sky130_fd_sc_hd__a2bb2o_4
Xoutput91 net91 VGND VGND VPWR VPWR Result[26] sky130_fd_sc_hd__buf_8
X_1292_ _0344_ _0420_ VGND VGND VPWR VPWR _0421_ sky130_fd_sc_hd__and2_1
Xoutput80 net80 VGND VGND VPWR VPWR Result[16] sky130_fd_sc_hd__buf_6
X_1361_ net230 net61 VGND VGND VPWR VPWR _0488_ sky130_fd_sc_hd__nor2_1
XFILLER_11_39 VGND VGND VPWR VPWR sky130_fd_sc_hd__decap_6
X_1559_ net173 net253 _0291_ VGND VGND VPWR VPWR _0679_ sky130_fd_sc_hd__a21oi_1
X_1628_ net154 _0744_ VGND VGND VPWR VPWR _0745_ sky130_fd_sc_hd__nand2_1
XFILLER_46_209 VGND VGND VPWR VPWR sky130_fd_sc_hd__fill_1
XFILLER_36_69 VGND VGND VPWR VPWR sky130_fd_sc_hd__fill_1
XFILLER_14_139 VGND VGND VPWR VPWR sky130_fd_sc_hd__fill_1
XFILLER_22_150 VGND VGND VPWR VPWR sky130_fd_sc_hd__decap_6
XFILLER_22_183 VGND VGND VPWR VPWR sky130_fd_sc_hd__fill_1
XTAP_TAPCELL_ROW_9_165 VGND VPWR sky130_fd_sc_hd__tapvpwrvgnd_1
XFILLER_9_143 VGND VGND VPWR VPWR sky130_fd_sc_hd__decap_4
XFILLER_13_150 VGND VGND VPWR VPWR sky130_fd_sc_hd__fill_1
XFILLER_13_183 VPWR VGND VPWR VGND sky130_ef_sc_hd__decap_12
XFILLER_47_3 VPWR VGND VPWR VGND sky130_ef_sc_hd__decap_12
X_1413_ net227 net63 VGND VGND VPWR VPWR _0538_ sky130_fd_sc_hd__nand2_1
XFILLER_36_253 VPWR VGND VPWR VGND sky130_ef_sc_hd__decap_12
XFILLER_3_51 VGND VGND VPWR VPWR sky130_fd_sc_hd__decap_4
X_1344_ _0159_ _0469_ _0470_ VGND VGND VPWR VPWR _0471_ sky130_fd_sc_hd__o21ai_1
X_1275_ net181 net166 net143 net112 VGND VGND VPWR VPWR _0404_ sky130_fd_sc_hd__a211o_1
XFILLER_51_234 VGND VGND VPWR VPWR sky130_fd_sc_hd__decap_4
XFILLER_22_27 VGND VGND VPWR VPWR sky130_fd_sc_hd__fill_1
Xfanout111 _0231_ VGND VGND VPWR VPWR net111 sky130_fd_sc_hd__buf_2
Xfanout133 _0208_ VGND VGND VPWR VPWR net133 sky130_fd_sc_hd__buf_2
Xfanout199 net206 VGND VGND VPWR VPWR net199 sky130_fd_sc_hd__buf_2
XTAP_TAPCELL_ROW_6_146 VGND VPWR sky130_fd_sc_hd__tapvpwrvgnd_1
Xfanout144 net145 VGND VGND VPWR VPWR net144 sky130_fd_sc_hd__clkbuf_4
Xfanout155 net156 VGND VGND VPWR VPWR net155 sky130_fd_sc_hd__buf_2
Xfanout122 _0411_ VGND VGND VPWR VPWR net122 sky130_fd_sc_hd__clkbuf_4
Xfanout188 net67 VGND VGND VPWR VPWR net188 sky130_fd_sc_hd__buf_8
Xfanout166 _0185_ VGND VGND VPWR VPWR net166 sky130_fd_sc_hd__buf_6
XFILLER_47_79 VGND VGND VPWR VPWR sky130_fd_sc_hd__fill_1
XFILLER_47_57 VGND VGND VPWR VPWR sky130_fd_sc_hd__fill_1
XFILLER_42_201 VGND VGND VPWR VPWR sky130_fd_sc_hd__fill_1
XPHY_EDGE_ROW_29_Right_29 VGND VGND VPWR VPWR sky130_fd_sc_hd__decap_3
XPHY_EDGE_ROW_38_Right_38 VGND VGND VPWR VPWR sky130_fd_sc_hd__decap_3
XFILLER_6_113 VPWR VGND VPWR VGND sky130_ef_sc_hd__decap_12
XFILLER_8_29 VPWR VGND VPWR VGND sky130_ef_sc_hd__decap_12
XFILLER_10_120 VGND VGND VPWR VPWR sky130_fd_sc_hd__decap_8
XFILLER_10_186 VGND VGND VPWR VPWR sky130_fd_sc_hd__decap_8
XFILLER_10_197 VGND VGND VPWR VPWR sky130_fd_sc_hd__decap_6
XPHY_EDGE_ROW_47_Right_47 VGND VGND VPWR VPWR sky130_fd_sc_hd__decap_3
X_1060_ net188 _0181_ VGND VGND VPWR VPWR _0193_ sky130_fd_sc_hd__or2_1
XFILLER_37_90 VPWR VGND VPWR VGND sky130_ef_sc_hd__decap_12
XFILLER_33_223 VGND VGND VPWR VPWR sky130_fd_sc_hd__fill_1
X_1962_ net141 _0049_ net130 VGND VGND VPWR VPWR _0050_ sky130_fd_sc_hd__o21a_1
XTAP_TAPCELL_ROW_28_270 VGND VPWR sky130_fd_sc_hd__tapvpwrvgnd_1
X_1893_ net243 net18 net223 VGND VGND VPWR VPWR _1000_ sky130_fd_sc_hd__mux2_1
X_1327_ _0190_ _0454_ _0452_ VGND VGND VPWR VPWR _0455_ sky130_fd_sc_hd__a21o_1
X_1258_ net233 net238 net250 net1 net216 net211 VGND VGND VPWR VPWR _0388_ sky130_fd_sc_hd__mux4_1
X_1189_ net198 net136 net128 _0121_ VGND VGND VPWR VPWR _0320_ sky130_fd_sc_hd__o2bb2a_1
XFILLER_17_27 VPWR VGND VPWR VGND sky130_ef_sc_hd__decap_12
XPHY_EDGE_ROW_49_Left_103 VGND VGND VPWR VPWR sky130_fd_sc_hd__decap_3
XFILLER_33_15 VPWR VGND VPWR VGND sky130_ef_sc_hd__decap_12
XFILLER_3_105 VGND VGND VPWR VPWR sky130_fd_sc_hd__fill_1
XFILLER_30_237 VGND VGND VPWR VPWR sky130_fd_sc_hd__decap_8
XTAP_TAPCELL_ROW_25_251 VGND VPWR sky130_fd_sc_hd__tapvpwrvgnd_1
XFILLER_15_234 VGND VGND VPWR VPWR sky130_fd_sc_hd__decap_6
XFILLER_15_267 VGND VGND VPWR VPWR sky130_fd_sc_hd__fill_2
XTAP_TAPCELL_ROW_17_207 VGND VPWR sky130_fd_sc_hd__tapvpwrvgnd_1
XFILLER_23_92 VPWR VGND VPWR VGND sky130_ef_sc_hd__decap_12
XFILLER_2_160 VGND VGND VPWR VPWR sky130_fd_sc_hd__decap_3
XFILLER_53_307 VGND VGND VPWR VPWR sky130_fd_sc_hd__fill_1
X_1112_ net200 _0233_ VGND VGND VPWR VPWR _0245_ sky130_fd_sc_hd__nor2_1
XFILLER_0_41 VGND VGND VPWR VPWR sky130_fd_sc_hd__decap_6
XTAP_TAPCELL_ROW_0_108 VGND VPWR sky130_fd_sc_hd__tapvpwrvgnd_1
XFILLER_0_85 VGND VGND VPWR VPWR sky130_fd_sc_hd__decap_3
X_1043_ net243 VGND VGND VPWR VPWR _0176_ sky130_fd_sc_hd__inv_2
X_1945_ net175 _0857_ _0951_ _0241_ net114 VGND VGND VPWR VPWR _0034_ sky130_fd_sc_hd__o221a_1
XFILLER_21_248 VGND VGND VPWR VPWR sky130_fd_sc_hd__decap_4
XTAP_TAPCELL_ROW_31_287 VGND VPWR sky130_fd_sc_hd__tapvpwrvgnd_1
X_1876_ _0175_ _0960_ _0961_ _0957_ VGND VGND VPWR VPWR _0983_ sky130_fd_sc_hd__a2bb2o_4
XTAP_TAPCELL_ROW_39_332 VGND VPWR sky130_fd_sc_hd__tapvpwrvgnd_1
XFILLER_28_15 VPWR VGND VPWR VGND sky130_ef_sc_hd__decap_12
XFILLER_44_307 VGND VGND VPWR VPWR sky130_fd_sc_hd__fill_1
XFILLER_12_215 VGND VGND VPWR VPWR sky130_fd_sc_hd__fill_2
XFILLER_8_208 VGND VGND VPWR VPWR sky130_fd_sc_hd__decap_8
XFILLER_47_178 VPWR VGND VPWR VGND sky130_ef_sc_hd__decap_12
XFILLER_47_101 VGND VGND VPWR VPWR sky130_fd_sc_hd__decap_4
XFILLER_34_91 VGND VGND VPWR VPWR sky130_fd_sc_hd__decap_6
X_1661_ net9 net8 net224 VGND VGND VPWR VPWR _0777_ sky130_fd_sc_hd__mux2_1
X_1730_ _0172_ _0841_ _0842_ VGND VGND VPWR VPWR _0843_ sky130_fd_sc_hd__o21ai_1
X_1592_ net189 net118 _0705_ net160 VGND VGND VPWR VPWR _0711_ sky130_fd_sc_hd__o22a_1
XTAP_TAPCELL_ROW_36_313 VGND VPWR sky130_fd_sc_hd__tapvpwrvgnd_1
X_1026_ net230 VGND VGND VPWR VPWR _0159_ sky130_fd_sc_hd__inv_2
X_1928_ net53 net150 net145 _0016_ VGND VGND VPWR VPWR _0017_ sky130_fd_sc_hd__a211o_1
X_1859_ net244 net50 VGND VGND VPWR VPWR _0967_ sky130_fd_sc_hd__or2_1
XFILLER_29_189 VGND VGND VPWR VPWR sky130_fd_sc_hd__fill_2
XFILLER_29_167 VGND VGND VPWR VPWR sky130_fd_sc_hd__fill_1
XFILLER_44_159 VGND VGND VPWR VPWR sky130_fd_sc_hd__fill_1
XTAP_TAPCELL_ROW_42_349 VGND VPWR sky130_fd_sc_hd__tapvpwrvgnd_1
XTAP_TAPCELL_ROW_50_393 VGND VPWR sky130_fd_sc_hd__tapvpwrvgnd_1
XFILLER_4_244 VGND VGND VPWR VPWR sky130_fd_sc_hd__decap_8
X_1713_ _0630_ _0826_ net175 VGND VGND VPWR VPWR _0827_ sky130_fd_sc_hd__mux2_1
X_1644_ _0760_ _0655_ net201 VGND VGND VPWR VPWR _0761_ sky130_fd_sc_hd__mux2_1
X_1575_ _0692_ _0693_ VGND VGND VPWR VPWR _0694_ sky130_fd_sc_hd__nor2_1
XFILLER_6_73 VGND VGND VPWR VPWR sky130_fd_sc_hd__decap_6
XFILLER_26_104 VGND VGND VPWR VPWR sky130_fd_sc_hd__fill_2
Xrebuffer23 net276 VGND VGND VPWR VPWR net275 sky130_fd_sc_hd__dlygate4sd1_1
XFILLER_41_107 VGND VGND VPWR VPWR sky130_fd_sc_hd__decap_4
Xrebuffer78 _0581_ VGND VGND VPWR VPWR net330 sky130_fd_sc_hd__dlygate4sd1_1
X_2058_ net103 net104 _0150_ VGND VGND VPWR VPWR _0151_ sky130_fd_sc_hd__or3_1
XFILLER_41_15 VPWR VGND VPWR VGND sky130_ef_sc_hd__decap_12
XFILLER_25_181 VPWR VGND VPWR VGND sky130_ef_sc_hd__decap_12
XFILLER_9_303 VGND VGND VPWR VPWR sky130_fd_sc_hd__fill_1
Xoutput70 net70 VGND VGND VPWR VPWR C sky130_fd_sc_hd__buf_6
X_1360_ net190 _0479_ _0486_ _0249_ VGND VGND VPWR VPWR _0487_ sky130_fd_sc_hd__a211o_1
Xoutput92 net92 VGND VGND VPWR VPWR Result[27] sky130_fd_sc_hd__buf_6
X_1291_ _0419_ _0234_ net200 VGND VGND VPWR VPWR _0420_ sky130_fd_sc_hd__mux2_1
Xoutput81 net81 VGND VGND VPWR VPWR Result[17] sky130_fd_sc_hd__buf_6
XFILLER_31_195 VPWR VGND VPWR VGND sky130_ef_sc_hd__decap_12
X_1558_ _0442_ _0449_ net176 VGND VGND VPWR VPWR _0678_ sky130_fd_sc_hd__mux2_1
X_1489_ net35 net147 net142 _0610_ VGND VGND VPWR VPWR _0611_ sky130_fd_sc_hd__a211o_1
X_1627_ net40 net147 net142 _0743_ VGND VGND VPWR VPWR _0744_ sky130_fd_sc_hd__a211o_1
XTAP_TAPCELL_ROW_52_400 VGND VPWR sky130_fd_sc_hd__tapvpwrvgnd_1
XFILLER_39_273 VGND VGND VPWR VPWR sky130_fd_sc_hd__fill_1
XFILLER_6_317 VGND VGND VPWR VPWR sky130_fd_sc_hd__fill_1
XFILLER_10_302 VGND VGND VPWR VPWR sky130_fd_sc_hd__decap_6
XFILLER_7_3 VPWR VGND VPWR VGND sky130_ef_sc_hd__decap_12
XTAP_TAPCELL_ROW_9_166 VGND VPWR sky130_fd_sc_hd__tapvpwrvgnd_1
XFILLER_9_100 VGND VGND VPWR VPWR sky130_fd_sc_hd__decap_6
XFILLER_9_122 VGND VGND VPWR VPWR sky130_fd_sc_hd__decap_3
XFILLER_13_195 VGND VGND VPWR VPWR sky130_fd_sc_hd__fill_2
X_1343_ net230 _0468_ net151 VGND VGND VPWR VPWR _0470_ sky130_fd_sc_hd__o21a_1
X_1412_ net227 net63 VGND VGND VPWR VPWR _0537_ sky130_fd_sc_hd__or2_1
XFILLER_51_213 VGND VGND VPWR VPWR sky130_fd_sc_hd__decap_4
XFILLER_51_202 VGND VGND VPWR VPWR sky130_fd_sc_hd__fill_2
XFILLER_36_265 VGND VGND VPWR VPWR sky130_fd_sc_hd__fill_1
XFILLER_36_221 VPWR VGND VPWR VGND sky130_ef_sc_hd__decap_12
X_1274_ net181 net146 VGND VGND VPWR VPWR _0403_ sky130_fd_sc_hd__nor2_2
XTAP_TAPCELL_ROW_14_190 VGND VPWR sky130_fd_sc_hd__tapvpwrvgnd_1
Xfanout189 net6 VGND VGND VPWR VPWR net189 sky130_fd_sc_hd__buf_2
Xfanout178 _0132_ VGND VGND VPWR VPWR net178 sky130_fd_sc_hd__buf_6
Xfanout167 _0185_ VGND VGND VPWR VPWR net167 sky130_fd_sc_hd__dlymetal6s2s_1
XTAP_TAPCELL_ROW_6_147 VGND VPWR sky130_fd_sc_hd__tapvpwrvgnd_1
Xfanout123 _0411_ VGND VGND VPWR VPWR net123 sky130_fd_sc_hd__clkbuf_2
Xfanout156 _0192_ VGND VGND VPWR VPWR net156 sky130_fd_sc_hd__clkbuf_2
Xfanout134 _0207_ VGND VGND VPWR VPWR net134 sky130_fd_sc_hd__clkbuf_4
Xfanout112 _0403_ VGND VGND VPWR VPWR net112 sky130_fd_sc_hd__buf_6
Xfanout145 _0199_ VGND VGND VPWR VPWR net145 sky130_fd_sc_hd__clkbuf_4
XFILLER_12_61 VGND VGND VPWR VPWR sky130_fd_sc_hd__decap_8
X_1961_ net239 net54 VGND VGND VPWR VPWR _0049_ sky130_fd_sc_hd__nor2_1
XTAP_TAPCELL_ROW_28_271 VGND VPWR sky130_fd_sc_hd__tapvpwrvgnd_1
X_1892_ _0994_ _0995_ _0997_ _0998_ VGND VGND VPWR VPWR _0999_ sky130_fd_sc_hd__or4_1
X_1326_ _0240_ _0305_ _0449_ net196 _0453_ VGND VGND VPWR VPWR _0454_ sky130_fd_sc_hd__a221o_1
X_1257_ _0237_ _0385_ _0386_ _0240_ VGND VGND VPWR VPWR _0387_ sky130_fd_sc_hd__a22o_1
X_1188_ _0313_ _0318_ VGND VGND VPWR VPWR _0319_ sky130_fd_sc_hd__xor2_1
XFILLER_17_39 VGND VGND VPWR VPWR sky130_fd_sc_hd__decap_4
XFILLER_33_27 VPWR VGND VPWR VGND sky130_ef_sc_hd__decap_12
XFILLER_32_290 VGND VGND VPWR VPWR sky130_fd_sc_hd__decap_6
XFILLER_47_305 VPWR VGND VPWR VGND sky130_ef_sc_hd__decap_12
XTAP_TAPCELL_ROW_17_208 VGND VPWR sky130_fd_sc_hd__tapvpwrvgnd_1
XTAP_TAPCELL_ROW_25_252 VGND VPWR sky130_fd_sc_hd__tapvpwrvgnd_1
XFILLER_23_60 VPWR VGND VPWR VGND sky130_ef_sc_hd__decap_12
XTAP_TAPCELL_ROW_48_377 VGND VPWR sky130_fd_sc_hd__tapvpwrvgnd_1
X_1111_ net174 _0230_ _0241_ _0243_ _0239_ VGND VGND VPWR VPWR _0244_ sky130_fd_sc_hd__o221a_1
XTAP_TAPCELL_ROW_0_109 VGND VPWR sky130_fd_sc_hd__tapvpwrvgnd_1
XFILLER_0_97 VGND VGND VPWR VPWR sky130_fd_sc_hd__fill_1
X_1042_ net244 VGND VGND VPWR VPWR _0175_ sky130_fd_sc_hd__inv_2
X_1875_ _0982_ VGND VGND VPWR VPWR net90 sky130_fd_sc_hd__inv_2
X_1944_ _1000_ _0032_ net178 VGND VGND VPWR VPWR _0033_ sky130_fd_sc_hd__mux2_1
XTAP_TAPCELL_ROW_31_288 VGND VPWR sky130_fd_sc_hd__tapvpwrvgnd_1
XFILLER_9_73 VGND VGND VPWR VPWR sky130_fd_sc_hd__fill_1
XFILLER_28_27 VGND VGND VPWR VPWR sky130_fd_sc_hd__fill_1
X_1309_ net231 _0435_ net151 VGND VGND VPWR VPWR _0437_ sky130_fd_sc_hd__o21a_1
XFILLER_44_15 VPWR VGND VPWR VGND sky130_ef_sc_hd__decap_12
XFILLER_12_227 VGND VGND VPWR VPWR sky130_fd_sc_hd__decap_4
XFILLER_47_113 VGND VGND VPWR VPWR sky130_fd_sc_hd__decap_4
X_1591_ net131 _0707_ VGND VGND VPWR VPWR _0710_ sky130_fd_sc_hd__nand2_1
X_1660_ _0774_ _0775_ net123 VGND VGND VPWR VPWR _0776_ sky130_fd_sc_hd__a21o_1
XFILLER_53_105 VGND VGND VPWR VPWR sky130_fd_sc_hd__fill_1
XFILLER_38_157 VPWR VGND VPWR VGND sky130_ef_sc_hd__decap_12
XFILLER_38_124 VGND VGND VPWR VPWR sky130_fd_sc_hd__decap_4
XFILLER_22_3 VPWR VGND VPWR VGND sky130_ef_sc_hd__decap_12
XTAP_TAPCELL_ROW_36_314 VGND VPWR sky130_fd_sc_hd__tapvpwrvgnd_1
XFILLER_14_29 VPWR VGND VPWR VGND sky130_ef_sc_hd__decap_12
X_1025_ net231 VGND VGND VPWR VPWR _0153_ sky130_fd_sc_hd__inv_2
X_1927_ net53 net164 VGND VGND VPWR VPWR _0016_ sky130_fd_sc_hd__nor2_1
X_1858_ net244 net50 VGND VGND VPWR VPWR _0966_ sky130_fd_sc_hd__nand2_1
XFILLER_39_15 VPWR VGND VPWR VGND sky130_ef_sc_hd__decap_12
X_1789_ net247 net47 VGND VGND VPWR VPWR _0900_ sky130_fd_sc_hd__nor2_1
XFILLER_29_113 VGND VGND VPWR VPWR sky130_fd_sc_hd__fill_2
XFILLER_17_308 VGND VGND VPWR VPWR sky130_fd_sc_hd__fill_2
XFILLER_45_91 VGND VGND VPWR VPWR sky130_fd_sc_hd__decap_4
X_1712_ _0825_ _0734_ net203 VGND VGND VPWR VPWR _0826_ sky130_fd_sc_hd__mux2_1
X_1643_ _0697_ _0759_ net180 VGND VGND VPWR VPWR _0760_ sky130_fd_sc_hd__mux2_1
XANTENNA_1 net69 VGND VGND VPWR VPWR sky130_fd_sc_hd__diode_2
XFILLER_6_41 VPWR VGND VPWR VGND sky130_ef_sc_hd__decap_12
X_1574_ net189 net154 _0691_ VGND VGND VPWR VPWR _0693_ sky130_fd_sc_hd__and3_1
XFILLER_26_127 VPWR VGND VPWR VGND sky130_ef_sc_hd__decap_12
X_2057_ net98 _0127_ _0133_ _0149_ VGND VGND VPWR VPWR _0150_ sky130_fd_sc_hd__or4_1
Xrebuffer24 net277 VGND VGND VPWR VPWR net276 sky130_fd_sc_hd__dlygate4sd1_1
XFILLER_19_190 VGND VGND VPWR VPWR sky130_fd_sc_hd__fill_1
XFILLER_41_27 VPWR VGND VPWR VGND sky130_ef_sc_hd__decap_12
XFILLER_25_193 VGND VGND VPWR VPWR sky130_fd_sc_hd__decap_4
XFILLER_17_127 VPWR VGND VPWR VGND sky130_ef_sc_hd__decap_12
XFILLER_17_149 VGND VGND VPWR VPWR sky130_fd_sc_hd__decap_8
Xoutput93 net93 VGND VGND VPWR VPWR Result[28] sky130_fd_sc_hd__buf_6
Xoutput71 net71 VGND VGND VPWR VPWR N sky130_fd_sc_hd__buf_2
Xoutput82 net82 VGND VGND VPWR VPWR Result[18] sky130_fd_sc_hd__buf_6
XFILLER_48_285 VPWR VGND VPWR VGND sky130_ef_sc_hd__decap_12
X_1290_ net27 net26 net238 net12 net217 net208 VGND VGND VPWR VPWR _0419_ sky130_fd_sc_hd__mux4_1
XFILLER_0_292 VGND VGND VPWR VPWR sky130_fd_sc_hd__decap_6
XFILLER_31_152 VGND VGND VPWR VPWR sky130_fd_sc_hd__decap_3
X_1626_ net40 net160 VGND VGND VPWR VPWR _0743_ sky130_fd_sc_hd__nor2_1
X_1488_ net35 net160 VGND VGND VPWR VPWR _0610_ sky130_fd_sc_hd__nor2_1
X_1557_ _0673_ _0675_ _0676_ _0058_ VGND VGND VPWR VPWR _0677_ sky130_fd_sc_hd__a31o_1
XTAP_TAPCELL_ROW_52_401 VGND VPWR sky130_fd_sc_hd__tapvpwrvgnd_1
XFILLER_52_15 VPWR VGND VPWR VGND sky130_ef_sc_hd__decap_12
XFILLER_36_27 VGND VGND VPWR VPWR sky130_fd_sc_hd__fill_1
XTAP_TAPCELL_ROW_9_167 VGND VPWR sky130_fd_sc_hd__tapvpwrvgnd_1
X_1273_ net233 _0180_ _0361_ _0356_ _0363_ VGND VGND VPWR VPWR _0402_ sky130_fd_sc_hd__a32o_2
X_1411_ _0534_ _0535_ net122 VGND VGND VPWR VPWR _0536_ sky130_fd_sc_hd__a21oi_1
X_1342_ net151 _0468_ VGND VGND VPWR VPWR _0469_ sky130_fd_sc_hd__nand2_1
XFILLER_36_233 VGND VGND VPWR VPWR sky130_fd_sc_hd__decap_8
XTAP_TAPCELL_ROW_14_191 VGND VPWR sky130_fd_sc_hd__tapvpwrvgnd_1
XFILLER_22_29 VGND VGND VPWR VPWR sky130_fd_sc_hd__decap_8
Xfanout113 net114 VGND VGND VPWR VPWR net113 sky130_fd_sc_hd__buf_2
X_1609_ net149 _0724_ _0726_ net116 VGND VGND VPWR VPWR _0727_ sky130_fd_sc_hd__o2bb2a_1
XFILLER_47_15 VPWR VGND VPWR VGND sky130_ef_sc_hd__decap_12
Xfanout179 _0132_ VGND VGND VPWR VPWR net179 sky130_fd_sc_hd__clkbuf_2
XFILLER_27_222 VGND VGND VPWR VPWR sky130_fd_sc_hd__fill_2
Xfanout146 _0197_ VGND VGND VPWR VPWR net146 sky130_fd_sc_hd__buf_8
XTAP_TAPCELL_ROW_6_148 VGND VPWR sky130_fd_sc_hd__tapvpwrvgnd_1
Xfanout135 net136 VGND VGND VPWR VPWR net135 sky130_fd_sc_hd__clkbuf_2
Xfanout124 _0410_ VGND VGND VPWR VPWR net124 sky130_fd_sc_hd__clkbuf_4
Xfanout157 _0192_ VGND VGND VPWR VPWR net157 sky130_fd_sc_hd__buf_2
XFILLER_12_95 VGND VGND VPWR VPWR sky130_fd_sc_hd__decap_8
XFILLER_2_321 VGND VGND VPWR VPWR sky130_fd_sc_hd__fill_1
XFILLER_33_225 VGND VGND VPWR VPWR sky130_fd_sc_hd__decap_6
XTAP_TAPCELL_ROW_28_272 VGND VPWR sky130_fd_sc_hd__tapvpwrvgnd_1
XPHY_EDGE_ROW_25_Left_79 VGND VGND VPWR VPWR sky130_fd_sc_hd__decap_3
XFILLER_18_233 VGND VGND VPWR VPWR sky130_fd_sc_hd__fill_2
XFILLER_18_288 VGND VGND VPWR VPWR sky130_fd_sc_hd__decap_8
XFILLER_53_91 VGND VGND VPWR VPWR sky130_fd_sc_hd__fill_1
X_1960_ net239 net54 _0261_ VGND VGND VPWR VPWR _0048_ sky130_fd_sc_hd__nand3_1
X_1891_ net167 net138 _0992_ VGND VGND VPWR VPWR _0998_ sky130_fd_sc_hd__mux2_1
XFILLER_52_3 VPWR VGND VPWR VGND sky130_ef_sc_hd__decap_12
X_1325_ _0237_ _0302_ net192 VGND VGND VPWR VPWR _0453_ sky130_fd_sc_hd__a21o_1
X_1256_ net228 net227 net226 net242 net218 net209 VGND VGND VPWR VPWR _0386_ sky130_fd_sc_hd__mux4_1
XFILLER_33_39 VPWR VGND VPWR VGND sky130_ef_sc_hd__decap_12
X_1187_ _0121_ _0316_ _0317_ VGND VGND VPWR VPWR _0318_ sky130_fd_sc_hd__o21ai_1
XFILLER_24_225 VPWR VGND VPWR VGND sky130_ef_sc_hd__decap_12
XFILLER_32_280 VGND VGND VPWR VPWR sky130_fd_sc_hd__decap_6
XFILLER_47_317 VGND VGND VPWR VPWR sky130_fd_sc_hd__decap_4
XTAP_TAPCELL_ROW_17_209 VGND VPWR sky130_fd_sc_hd__tapvpwrvgnd_1
XTAP_TAPCELL_ROW_25_253 VGND VPWR sky130_fd_sc_hd__tapvpwrvgnd_1
XFILLER_23_72 VPWR VGND VPWR VGND sky130_ef_sc_hd__decap_12
X_1110_ net232 net231 net230 net228 net218 net209 VGND VGND VPWR VPWR _0243_ sky130_fd_sc_hd__mux4_1
XTAP_TAPCELL_ROW_48_378 VGND VPWR sky130_fd_sc_hd__tapvpwrvgnd_1
XFILLER_0_32 VGND VGND VPWR VPWR sky130_fd_sc_hd__decap_6
X_1041_ net246 VGND VGND VPWR VPWR _0174_ sky130_fd_sc_hd__inv_2
X_1943_ net240 net20 net223 VGND VGND VPWR VPWR _0032_ sky130_fd_sc_hd__mux2_1
X_1874_ _0981_ net282 VGND VGND VPWR VPWR _0982_ sky130_fd_sc_hd__nand2_4
XFILLER_44_309 VPWR VGND VPWR VGND sky130_ef_sc_hd__decap_12
X_1239_ net234 net158 VGND VGND VPWR VPWR _0369_ sky130_fd_sc_hd__nand2_1
X_1308_ net151 _0435_ VGND VGND VPWR VPWR _0436_ sky130_fd_sc_hd__nand2_1
XFILLER_44_27 VGND VGND VPWR VPWR sky130_fd_sc_hd__fill_1
XTAP_TAPCELL_ROW_22_234 VGND VPWR sky130_fd_sc_hd__tapvpwrvgnd_1
XFILLER_47_125 VGND VGND VPWR VPWR sky130_fd_sc_hd__decap_4
XFILLER_18_94 VGND VGND VPWR VPWR sky130_fd_sc_hd__fill_2
XFILLER_7_210 VGND VGND VPWR VPWR sky130_fd_sc_hd__decap_8
XFILLER_11_250 VGND VGND VPWR VPWR sky130_fd_sc_hd__decap_3
X_1590_ net139 _0705_ _0707_ VGND VGND VPWR VPWR _0709_ sky130_fd_sc_hd__or3b_1
XFILLER_38_169 VGND VGND VPWR VPWR sky130_fd_sc_hd__fill_1
XTAP_TAPCELL_ROW_36_315 VGND VPWR sky130_fd_sc_hd__tapvpwrvgnd_1
XFILLER_26_309 VGND VGND VPWR VPWR sky130_fd_sc_hd__fill_1
XFILLER_15_3 VPWR VGND VPWR VGND sky130_ef_sc_hd__decap_12
X_1024_ net232 VGND VGND VPWR VPWR _0143_ sky130_fd_sc_hd__inv_2
XFILLER_46_191 VGND VGND VPWR VPWR sky130_fd_sc_hd__decap_4
XPHY_EDGE_ROW_28_Left_82 VGND VGND VPWR VPWR sky130_fd_sc_hd__decap_3
X_1788_ _0345_ _0482_ _0860_ VGND VGND VPWR VPWR _0899_ sky130_fd_sc_hd__o21ai_1
XFILLER_30_29 VGND VGND VPWR VPWR sky130_fd_sc_hd__decap_4
XPHY_EDGE_ROW_12_Left_66 VGND VGND VPWR VPWR sky130_fd_sc_hd__decap_3
X_1857_ _0964_ _0963_ VGND VGND VPWR VPWR _0965_ sky130_fd_sc_hd__nand2_1
X_1926_ _0177_ _1011_ _1012_ _1008_ VGND VGND VPWR VPWR _0015_ sky130_fd_sc_hd__a2bb2o_4
XFILLER_39_27 VPWR VGND VPWR VGND sky130_ef_sc_hd__decap_12
XFILLER_44_106 VGND VGND VPWR VPWR sky130_fd_sc_hd__decap_4
XFILLER_29_169 VPWR VGND VPWR VGND sky130_ef_sc_hd__decap_12
XFILLER_25_320 VGND VGND VPWR VPWR sky130_fd_sc_hd__fill_2
XFILLER_4_257 VGND VGND VPWR VPWR sky130_fd_sc_hd__fill_1
XFILLER_20_73 VGND VGND VPWR VPWR sky130_fd_sc_hd__decap_4
XFILLER_35_128 VGND VGND VPWR VPWR sky130_fd_sc_hd__decap_4
XFILLER_29_82 VGND VGND VPWR VPWR sky130_fd_sc_hd__fill_1
XFILLER_45_81 VGND VGND VPWR VPWR sky130_fd_sc_hd__decap_4
XTAP_TAPCELL_ROW_41_340 VGND VPWR sky130_fd_sc_hd__tapvpwrvgnd_1
XFILLER_28_191 VGND VGND VPWR VPWR sky130_fd_sc_hd__decap_4
X_1711_ _0777_ _0824_ net178 VGND VGND VPWR VPWR _0825_ sky130_fd_sc_hd__mux2_1
X_1642_ net8 net7 net220 VGND VGND VPWR VPWR _0759_ sky130_fd_sc_hd__mux2_1
XFILLER_6_53 VPWR VGND VPWR VGND sky130_ef_sc_hd__decap_12
XANTENNA_2 net84 VGND VGND VPWR VPWR sky130_fd_sc_hd__diode_2
X_1573_ net189 _0691_ net154 VGND VGND VPWR VPWR _0692_ sky130_fd_sc_hd__o21ai_1
XFILLER_26_139 VGND VGND VPWR VPWR sky130_fd_sc_hd__fill_1
X_2056_ net73 net84 net95 VGND VGND VPWR VPWR _0149_ sky130_fd_sc_hd__or3_1
Xrebuffer25 net278 VGND VGND VPWR VPWR net277 sky130_fd_sc_hd__dlygate4sd1_1
XFILLER_41_39 VPWR VGND VPWR VGND sky130_ef_sc_hd__decap_12
X_1909_ net52 net138 net130 _0177_ VGND VGND VPWR VPWR _1015_ sky130_fd_sc_hd__o2bb2a_1
XFILLER_17_139 VGND VGND VPWR VPWR sky130_fd_sc_hd__fill_1
XFILLER_40_197 VPWR VGND VPWR VGND sky130_ef_sc_hd__decap_12
Xoutput72 net72 VGND VGND VPWR VPWR P sky130_fd_sc_hd__buf_6
Xoutput94 net94 VGND VGND VPWR VPWR Result[29] sky130_fd_sc_hd__buf_6
Xoutput83 net83 VGND VGND VPWR VPWR Result[19] sky130_fd_sc_hd__buf_6
XFILLER_48_297 VGND VGND VPWR VPWR sky130_fd_sc_hd__decap_8
X_1625_ _0167_ _0718_ _0719_ _0715_ VGND VGND VPWR VPWR _0742_ sky130_fd_sc_hd__a2bb2o_4
X_1556_ net134 _0670_ _0672_ net139 _0674_ VGND VGND VPWR VPWR _0676_ sky130_fd_sc_hd__o221a_1
X_1487_ _0584_ _0581_ _0585_ VGND VGND VPWR VPWR _0609_ sky130_fd_sc_hd__a21o_1
XTAP_TAPCELL_ROW_52_402 VGND VPWR sky130_fd_sc_hd__tapvpwrvgnd_1
XFILLER_52_27 VGND VGND VPWR VPWR sky130_fd_sc_hd__fill_1
X_2039_ _0129_ _0130_ VGND VGND VPWR VPWR _0131_ sky130_fd_sc_hd__xnor2_1
XFILLER_22_197 VGND VGND VPWR VPWR sky130_fd_sc_hd__fill_1
XFILLER_45_234 VGND VGND VPWR VPWR sky130_fd_sc_hd__fill_1
XFILLER_45_223 VGND VGND VPWR VPWR sky130_fd_sc_hd__fill_1
XFILLER_26_83 VGND VGND VPWR VPWR sky130_fd_sc_hd__fill_1
X_1410_ net63 net135 net127 _0161_ VGND VGND VPWR VPWR _0535_ sky130_fd_sc_hd__o2bb2a_1
XFILLER_3_65 VGND VGND VPWR VPWR sky130_fd_sc_hd__fill_2
X_1272_ _0401_ VGND VGND VPWR VPWR net98 sky130_fd_sc_hd__inv_2
X_1341_ net61 net159 net139 _0467_ VGND VGND VPWR VPWR _0468_ sky130_fd_sc_hd__o211ai_1
XTAP_TAPCELL_ROW_14_192 VGND VPWR sky130_fd_sc_hd__tapvpwrvgnd_1
Xfanout114 _0295_ VGND VGND VPWR VPWR net114 sky130_fd_sc_hd__buf_2
XTAP_TAPCELL_ROW_6_149 VGND VPWR sky130_fd_sc_hd__tapvpwrvgnd_1
X_1608_ _0724_ _0725_ VGND VGND VPWR VPWR _0726_ sky130_fd_sc_hd__nor2_1
Xfanout147 net148 VGND VGND VPWR VPWR net147 sky130_fd_sc_hd__clkbuf_4
Xfanout136 _0206_ VGND VGND VPWR VPWR net136 sky130_fd_sc_hd__clkbuf_2
X_1539_ _0249_ _0659_ _0651_ _0643_ VGND VGND VPWR VPWR _0660_ sky130_fd_sc_hd__o211a_4
Xfanout125 net126 VGND VGND VPWR VPWR net125 sky130_fd_sc_hd__clkbuf_4
XFILLER_47_27 VPWR VGND VPWR VGND sky130_ef_sc_hd__decap_12
Xfanout169 net170 VGND VGND VPWR VPWR net169 sky130_fd_sc_hd__clkbuf_4
Xfanout158 _0187_ VGND VGND VPWR VPWR net158 sky130_fd_sc_hd__buf_8
XFILLER_6_105 VGND VGND VPWR VPWR sky130_fd_sc_hd__fill_1
XFILLER_10_145 VGND VGND VPWR VPWR sky130_fd_sc_hd__fill_1
XPHY_EDGE_ROW_0_Left_54 VGND VGND VPWR VPWR sky130_fd_sc_hd__decap_3
XPHY_EDGE_ROW_16_Right_16 VGND VGND VPWR VPWR sky130_fd_sc_hd__decap_3
XFILLER_18_245 VGND VGND VPWR VPWR sky130_fd_sc_hd__decap_6
XFILLER_18_267 VGND VGND VPWR VPWR sky130_fd_sc_hd__fill_1
XFILLER_53_81 VGND VGND VPWR VPWR sky130_fd_sc_hd__decap_3
XFILLER_41_281 VGND VGND VPWR VPWR sky130_fd_sc_hd__decap_4
XPHY_EDGE_ROW_25_Right_25 VGND VGND VPWR VPWR sky130_fd_sc_hd__decap_3
X_1890_ _0993_ _0996_ VGND VGND VPWR VPWR _0997_ sky130_fd_sc_hd__nor2_1
XFILLER_45_3 VPWR VGND VPWR VGND sky130_ef_sc_hd__decap_12
XFILLER_5_193 VGND VGND VPWR VPWR sky130_fd_sc_hd__decap_8
X_1255_ net26 net27 net231 net230 net218 net209 VGND VGND VPWR VPWR _0385_ sky130_fd_sc_hd__mux4_1
X_1324_ net199 _0450_ _0451_ _0344_ VGND VGND VPWR VPWR _0452_ sky130_fd_sc_hd__o211a_1
XPHY_EDGE_ROW_34_Right_34 VGND VGND VPWR VPWR sky130_fd_sc_hd__decap_3
X_1186_ net238 _0315_ net153 VGND VGND VPWR VPWR _0317_ sky130_fd_sc_hd__o21a_1
XFILLER_24_237 VGND VGND VPWR VPWR sky130_fd_sc_hd__decap_4
XPHY_EDGE_ROW_43_Right_43 VGND VGND VPWR VPWR sky130_fd_sc_hd__decap_3
XPHY_EDGE_ROW_42_Left_96 VGND VGND VPWR VPWR sky130_fd_sc_hd__decap_3
XPHY_EDGE_ROW_52_Right_52 VGND VGND VPWR VPWR sky130_fd_sc_hd__decap_3
XTAP_TAPCELL_ROW_25_254 VGND VPWR sky130_fd_sc_hd__tapvpwrvgnd_1
XFILLER_23_84 VGND VGND VPWR VPWR sky130_fd_sc_hd__fill_2
XFILLER_2_141 VGND VGND VPWR VPWR sky130_fd_sc_hd__decap_6
XFILLER_48_70 VGND VGND VPWR VPWR sky130_fd_sc_hd__decap_4
XFILLER_38_307 VGND VGND VPWR VPWR sky130_fd_sc_hd__fill_1
X_1040_ net247 VGND VGND VPWR VPWR _0173_ sky130_fd_sc_hd__inv_2
XTAP_TAPCELL_ROW_48_379 VGND VPWR sky130_fd_sc_hd__tapvpwrvgnd_1
X_1942_ net125 _0030_ VGND VGND VPWR VPWR _0031_ sky130_fd_sc_hd__nor2_1
XFILLER_0_55 VGND VGND VPWR VPWR sky130_fd_sc_hd__fill_1
X_1873_ _0965_ net124 _0973_ _0980_ VGND VGND VPWR VPWR _0981_ sky130_fd_sc_hd__a211o_4
XFILLER_28_29 VGND VGND VPWR VPWR sky130_fd_sc_hd__decap_6
XFILLER_52_321 VGND VGND VPWR VPWR sky130_fd_sc_hd__fill_1
X_1169_ _0237_ net113 _0298_ VGND VGND VPWR VPWR _0301_ sky130_fd_sc_hd__and3_1
X_1238_ net234 net158 VGND VGND VPWR VPWR _0368_ sky130_fd_sc_hd__and2_2
X_1307_ net60 net159 net139 _0434_ VGND VGND VPWR VPWR _0435_ sky130_fd_sc_hd__o211ai_1
XTAP_TAPCELL_ROW_22_235 VGND VPWR sky130_fd_sc_hd__tapvpwrvgnd_1
XFILLER_47_137 VGND VGND VPWR VPWR sky130_fd_sc_hd__decap_8
XFILLER_34_72 VGND VGND VPWR VPWR sky130_fd_sc_hd__decap_6
XFILLER_11_240 VGND VGND VPWR VPWR sky130_fd_sc_hd__fill_1
X_1023_ net208 VGND VGND VPWR VPWR _0132_ sky130_fd_sc_hd__inv_4
XFILLER_46_170 VGND VGND VPWR VPWR sky130_fd_sc_hd__decap_3
XTAP_TAPCELL_ROW_36_316 VGND VPWR sky130_fd_sc_hd__tapvpwrvgnd_1
XTAP_TAPCELL_ROW_44_360 VGND VPWR sky130_fd_sc_hd__tapvpwrvgnd_1
X_1925_ net170 _0014_ VGND VGND VPWR VPWR net92 sky130_fd_sc_hd__nor2_2
X_1787_ _0479_ _0897_ VGND VGND VPWR VPWR _0898_ sky130_fd_sc_hd__nand2_1
X_1856_ net50 net138 net129 _0175_ VGND VGND VPWR VPWR _0964_ sky130_fd_sc_hd__o2bb2a_1
XFILLER_39_39 VPWR VGND VPWR VGND sky130_ef_sc_hd__decap_12
XPHY_EDGE_ROW_2_Right_2 VGND VGND VPWR VPWR sky130_fd_sc_hd__decap_3
XFILLER_52_195 VGND VGND VPWR VPWR sky130_fd_sc_hd__fill_1
XFILLER_37_192 VPWR VGND VPWR VGND sky130_ef_sc_hd__decap_12
XFILLER_20_41 VGND VGND VPWR VPWR sky130_fd_sc_hd__fill_1
XFILLER_20_85 VGND VGND VPWR VPWR sky130_fd_sc_hd__decap_3
XFILLER_29_72 VGND VGND VPWR VPWR sky130_fd_sc_hd__fill_1
XTAP_TAPCELL_ROW_41_341 VGND VPWR sky130_fd_sc_hd__tapvpwrvgnd_1
X_1710_ net11 net10 net336 VGND VGND VPWR VPWR _0824_ sky130_fd_sc_hd__mux2_1
XFILLER_6_65 VGND VGND VPWR VPWR sky130_fd_sc_hd__fill_1
X_1572_ net38 net160 net139 _0690_ VGND VGND VPWR VPWR _0691_ sky130_fd_sc_hd__o211ai_1
X_1641_ _0755_ _0757_ net68 VGND VGND VPWR VPWR _0758_ sky130_fd_sc_hd__o21ai_1
XFILLER_3_291 VPWR VGND VPWR VGND sky130_ef_sc_hd__decap_12
X_2055_ _0148_ _0109_ VGND VGND VPWR VPWR net72 sky130_fd_sc_hd__xnor2_2
Xrebuffer26 net279 VGND VGND VPWR VPWR net278 sky130_fd_sc_hd__dlygate4sd1_1
XFILLER_19_181 VGND VGND VPWR VPWR sky130_fd_sc_hd__fill_1
XFILLER_34_195 VGND VGND VPWR VPWR sky130_fd_sc_hd__fill_1
X_1839_ _0944_ _0947_ _0058_ VGND VGND VPWR VPWR _0948_ sky130_fd_sc_hd__a21o_1
X_1908_ _1008_ _1013_ VGND VGND VPWR VPWR _1014_ sky130_fd_sc_hd__xor2_1
XFILLER_40_121 VPWR VGND VPWR VGND sky130_ef_sc_hd__decap_12
Xoutput73 net73 VGND VGND VPWR VPWR Result[0] sky130_fd_sc_hd__buf_6
XFILLER_0_261 VGND VGND VPWR VPWR sky130_fd_sc_hd__decap_6
Xoutput84 net84 VGND VGND VPWR VPWR Result[1] sky130_fd_sc_hd__buf_2
Xoutput95 net334 VGND VGND VPWR VPWR Result[2] sky130_fd_sc_hd__buf_6
XFILLER_16_184 VGND VGND VPWR VPWR sky130_fd_sc_hd__decap_6
XFILLER_31_187 VGND VGND VPWR VPWR sky130_fd_sc_hd__decap_4
X_1555_ net166 _0670_ net118 net207 VGND VGND VPWR VPWR _0675_ sky130_fd_sc_hd__o2bb2a_1
X_1624_ net169 _0741_ VGND VGND VPWR VPWR net79 sky130_fd_sc_hd__nor2_4
XFILLER_36_29 VPWR VGND VPWR VGND sky130_ef_sc_hd__decap_12
X_1486_ _0608_ VGND VGND VPWR VPWR net74 sky130_fd_sc_hd__inv_2
XTAP_TAPCELL_ROW_52_403 VGND VPWR sky130_fd_sc_hd__tapvpwrvgnd_1
X_2038_ net335 _0401_ VGND VGND VPWR VPWR _0130_ sky130_fd_sc_hd__xnor2_1
XFILLER_22_132 VGND VGND VPWR VPWR sky130_fd_sc_hd__fill_1
XFILLER_6_309 VGND VGND VPWR VPWR sky130_fd_sc_hd__decap_8
XFILLER_42_94 VGND VGND VPWR VPWR sky130_fd_sc_hd__decap_8
XFILLER_42_83 VGND VGND VPWR VPWR sky130_fd_sc_hd__fill_1
XFILLER_42_61 VGND VGND VPWR VPWR sky130_fd_sc_hd__fill_1
XFILLER_9_169 VGND VGND VPWR VPWR sky130_fd_sc_hd__fill_2
XFILLER_5_320 VGND VGND VPWR VPWR sky130_fd_sc_hd__fill_2
Xrebuffer6 _0715_ VGND VGND VPWR VPWR net258 sky130_fd_sc_hd__dlygate4sd1_1
X_1340_ net61 net147 VGND VGND VPWR VPWR _0467_ sky130_fd_sc_hd__nand2_1
XFILLER_3_99 VGND VGND VPWR VPWR sky130_fd_sc_hd__decap_6
XFILLER_3_77 VGND VGND VPWR VPWR sky130_fd_sc_hd__decap_8
XFILLER_3_55 VGND VGND VPWR VPWR sky130_fd_sc_hd__fill_1
X_1271_ _0367_ _0393_ _0400_ VGND VGND VPWR VPWR _0401_ sky130_fd_sc_hd__and3_2
XFILLER_36_279 VGND VGND VPWR VPWR sky130_fd_sc_hd__decap_3
XTAP_TAPCELL_ROW_14_193 VGND VPWR sky130_fd_sc_hd__tapvpwrvgnd_1
X_1538_ net192 _0652_ _0658_ VGND VGND VPWR VPWR _0659_ sky130_fd_sc_hd__a21oi_1
Xfanout126 _0251_ VGND VGND VPWR VPWR net126 sky130_fd_sc_hd__clkbuf_4
X_1607_ net183 net39 VGND VGND VPWR VPWR _0725_ sky130_fd_sc_hd__nor2_1
Xfanout115 _0257_ VGND VGND VPWR VPWR net115 sky130_fd_sc_hd__buf_6
Xfanout159 net161 VGND VGND VPWR VPWR net159 sky130_fd_sc_hd__buf_2
X_1469_ _0163_ net256 net131 _0591_ VGND VGND VPWR VPWR _0592_ sky130_fd_sc_hd__a22o_1
Xfanout137 net138 VGND VGND VPWR VPWR net137 sky130_fd_sc_hd__buf_2
Xfanout148 _0196_ VGND VGND VPWR VPWR net148 sky130_fd_sc_hd__clkbuf_2
XFILLER_47_39 VPWR VGND VPWR VGND sky130_ef_sc_hd__decap_12
XFILLER_27_279 VGND VGND VPWR VPWR sky130_fd_sc_hd__fill_1
XFILLER_27_235 VPWR VGND VPWR VGND sky130_ef_sc_hd__decap_12
XFILLER_27_213 VGND VGND VPWR VPWR sky130_fd_sc_hd__fill_1
XFILLER_5_3 VPWR VGND VPWR VGND sky130_ef_sc_hd__decap_12
XFILLER_12_53 VGND VGND VPWR VPWR sky130_fd_sc_hd__decap_4
XFILLER_53_71 VGND VGND VPWR VPWR sky130_fd_sc_hd__fill_1
XTAP_TAPCELL_ROW_11_174 VGND VPWR sky130_fd_sc_hd__tapvpwrvgnd_1
XFILLER_38_3 VPWR VGND VPWR VGND sky130_ef_sc_hd__decap_12
X_1323_ net198 _0299_ VGND VGND VPWR VPWR _0451_ sky130_fd_sc_hd__nand2_1
XFILLER_5_172 VPWR VGND VPWR VGND sky130_ef_sc_hd__decap_12
X_1254_ _0382_ _0383_ net205 VGND VGND VPWR VPWR _0384_ sky130_fd_sc_hd__mux2_1
X_1185_ net153 _0315_ VGND VGND VPWR VPWR _0316_ sky130_fd_sc_hd__nand2_1
XTAP_TAPCELL_ROW_25_255 VGND VPWR sky130_fd_sc_hd__tapvpwrvgnd_1
XFILLER_2_197 VGND VGND VPWR VPWR sky130_fd_sc_hd__decap_6
XFILLER_2_186 VGND VGND VPWR VPWR sky130_fd_sc_hd__decap_3
XFILLER_0_23 VGND VGND VPWR VPWR sky130_fd_sc_hd__decap_4
XFILLER_0_67 VGND VGND VPWR VPWR sky130_fd_sc_hd__fill_1
XFILLER_24_9 VPWR VGND VPWR VGND sky130_ef_sc_hd__decap_12
X_1941_ net110 _0025_ _0026_ _0029_ VGND VGND VPWR VPWR _0030_ sky130_fd_sc_hd__o211a_1
X_1872_ _0974_ _0979_ net184 VGND VGND VPWR VPWR _0980_ sky130_fd_sc_hd__o21a_1
X_1306_ net60 net147 VGND VGND VPWR VPWR _0434_ sky130_fd_sc_hd__nand2_1
XFILLER_44_29 VPWR VGND VPWR VGND sky130_ef_sc_hd__decap_12
X_1099_ net250 net217 VGND VGND VPWR VPWR _0232_ sky130_fd_sc_hd__nand2_1
X_1168_ net198 _0299_ VGND VGND VPWR VPWR _0300_ sky130_fd_sc_hd__nor2_1
X_1237_ _0180_ _0366_ VGND VGND VPWR VPWR _0367_ sky130_fd_sc_hd__nand2_1
XTAP_TAPCELL_ROW_30_280 VGND VPWR sky130_fd_sc_hd__tapvpwrvgnd_1
XTAP_TAPCELL_ROW_22_236 VGND VPWR sky130_fd_sc_hd__tapvpwrvgnd_1
XFILLER_47_149 VGND VGND VPWR VPWR sky130_fd_sc_hd__decap_4
XFILLER_47_105 VGND VGND VPWR VPWR sky130_fd_sc_hd__fill_1
XFILLER_18_41 VPWR VGND VPWR VGND sky130_ef_sc_hd__decap_12
XFILLER_50_94 VGND VGND VPWR VPWR sky130_fd_sc_hd__decap_6
XFILLER_7_223 VGND VGND VPWR VPWR sky130_fd_sc_hd__fill_1
XFILLER_7_234 VGND VGND VPWR VPWR sky130_fd_sc_hd__fill_1
XFILLER_7_278 VGND VGND VPWR VPWR sky130_fd_sc_hd__fill_2
XFILLER_11_274 VGND VGND VPWR VPWR sky130_fd_sc_hd__fill_1
XFILLER_38_116 VGND VGND VPWR VPWR sky130_fd_sc_hd__fill_1
XFILLER_38_138 VGND VGND VPWR VPWR sky130_fd_sc_hd__fill_2
X_1022_ net238 VGND VGND VPWR VPWR _0121_ sky130_fd_sc_hd__inv_2
X_1924_ _0012_ _0013_ VGND VGND VPWR VPWR _0014_ sky130_fd_sc_hd__nor2_4
X_1855_ _0962_ _0957_ VGND VGND VPWR VPWR _0963_ sky130_fd_sc_hd__xor2_1
X_1786_ _0358_ _0699_ _0896_ _0344_ net191 VGND VGND VPWR VPWR _0897_ sky130_fd_sc_hd__a221oi_1
XFILLER_44_119 VGND VGND VPWR VPWR sky130_fd_sc_hd__decap_3
XTAP_TAPCELL_ROW_41_342 VGND VPWR sky130_fd_sc_hd__tapvpwrvgnd_1
XFILLER_6_99 VGND VGND VPWR VPWR sky130_fd_sc_hd__decap_6
X_1571_ net38 net148 VGND VGND VPWR VPWR _0690_ sky130_fd_sc_hd__nand2_1
X_1640_ _0751_ _0753_ _0756_ _0169_ _0754_ VGND VGND VPWR VPWR _0757_ sky130_fd_sc_hd__a221o_1
Xrebuffer27 _0792_ VGND VGND VPWR VPWR net279 sky130_fd_sc_hd__dlymetal6s2s_1
XFILLER_20_3 VPWR VGND VPWR VGND sky130_ef_sc_hd__decap_12
X_2054_ _0111_ _0147_ VGND VGND VPWR VPWR _0148_ sky130_fd_sc_hd__xnor2_1
X_1838_ net245 net49 _0260_ _0946_ VGND VGND VPWR VPWR _0947_ sky130_fd_sc_hd__a31o_1
X_1907_ _0177_ _1011_ _1012_ VGND VGND VPWR VPWR _1013_ sky130_fd_sc_hd__o21ai_1
X_1769_ net140 _0878_ _0880_ net129 VGND VGND VPWR VPWR _0881_ sky130_fd_sc_hd__o211a_1
XFILLER_40_133 VGND VGND VPWR VPWR sky130_fd_sc_hd__decap_6
XFILLER_31_74 VPWR VGND VPWR VGND sky130_ef_sc_hd__decap_12
Xoutput96 net96 VGND VGND VPWR VPWR Result[30] sky130_fd_sc_hd__buf_6
XFILLER_48_233 VGND VGND VPWR VPWR sky130_fd_sc_hd__fill_1
Xoutput85 net85 VGND VGND VPWR VPWR Result[20] sky130_fd_sc_hd__buf_6
Xoutput74 net74 VGND VGND VPWR VPWR Result[10] sky130_fd_sc_hd__buf_4
XFILLER_31_111 VGND VGND VPWR VPWR sky130_fd_sc_hd__fill_1
X_1623_ net125 _0731_ _0740_ _0723_ VGND VGND VPWR VPWR _0741_ sky130_fd_sc_hd__o211a_4
X_1554_ net131 _0671_ VGND VGND VPWR VPWR _0674_ sky130_fd_sc_hd__nand2_1
X_1485_ _0607_ _0183_ VGND VGND VPWR VPWR _0608_ sky130_fd_sc_hd__nand2_4
.ends
